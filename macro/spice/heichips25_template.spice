* NGSPICE file created from heichips25_template.ext - technology: ihp-sg13g2

* Black-box entry subcircuit for sg13g2_decap_8 abstract view
.subckt sg13g2_decap_8 VDD VSS
.ends

* Black-box entry subcircuit for sg13g2_tiehi abstract view
.subckt sg13g2_tiehi VDD VSS L_HI
.ends

* Black-box entry subcircuit for sg13g2_and2_1 abstract view
.subckt sg13g2_and2_1 A B X VDD VSS
.ends

* Black-box entry subcircuit for sg13g2_nor2b_1 abstract view
.subckt sg13g2_nor2b_1 A B_N Y VDD VSS
.ends

* Black-box entry subcircuit for sg13g2_decap_4 abstract view
.subckt sg13g2_decap_4 VDD VSS
.ends

* Black-box entry subcircuit for sg13g2_dfrbpq_1 abstract view
.subckt sg13g2_dfrbpq_1 RESET_B VSS VDD D Q CLK
.ends

* Black-box entry subcircuit for sg13g2_fill_1 abstract view
.subckt sg13g2_fill_1 VDD VSS
.ends

* Black-box entry subcircuit for sg13g2_fill_2 abstract view
.subckt sg13g2_fill_2 VDD VSS
.ends

* Black-box entry subcircuit for sg13g2_nand4_1 abstract view
.subckt sg13g2_nand4_1 B C A Y VDD VSS D
.ends

* Black-box entry subcircuit for sg13g2_nand2_2 abstract view
.subckt sg13g2_nand2_2 Y A B VDD VSS
.ends

* Black-box entry subcircuit for sg13g2_xor2_1 abstract view
.subckt sg13g2_xor2_1 B A X VDD VSS
.ends

* Black-box entry subcircuit for sg13g2_a21oi_1 abstract view
.subckt sg13g2_a21oi_1 VSS VDD A1 A2 Y B1
.ends

* Black-box entry subcircuit for sg13g2_nand2_1 abstract view
.subckt sg13g2_nand2_1 Y A B VDD VSS
.ends

* Black-box entry subcircuit for sg13g2_o21ai_1 abstract view
.subckt sg13g2_o21ai_1 B1 VDD Y VSS A1 A2
.ends

* Black-box entry subcircuit for sg13g2_buf_8 abstract view
.subckt sg13g2_buf_8 A X VDD VSS
.ends

* Black-box entry subcircuit for sg13g2_a21o_1 abstract view
.subckt sg13g2_a21o_1 A2 A1 B1 X VDD VSS
.ends

* Black-box entry subcircuit for sg13g2_a22oi_1 abstract view
.subckt sg13g2_a22oi_1 Y B1 B2 A2 A1 VDD VSS
.ends

* Black-box entry subcircuit for sg13g2_xnor2_1 abstract view
.subckt sg13g2_xnor2_1 Y A B VDD VSS
.ends

* Black-box entry subcircuit for sg13g2_or2_1 abstract view
.subckt sg13g2_or2_1 VSS VDD X B A
.ends

* Black-box entry subcircuit for sg13g2_a21o_2 abstract view
.subckt sg13g2_a21o_2 A2 A1 B1 X VDD VSS
.ends

* Black-box entry subcircuit for sg13g2_inv_4 abstract view
.subckt sg13g2_inv_4 A Y VDD VSS
.ends

* Black-box entry subcircuit for sg13g2_dlygate4sd3_1 abstract view
.subckt sg13g2_dlygate4sd3_1 A VDD VSS X
.ends

* Black-box entry subcircuit for sg13g2_nor2_1 abstract view
.subckt sg13g2_nor2_1 A B Y VDD VSS
.ends

* Black-box entry subcircuit for sg13g2_nor3_1 abstract view
.subckt sg13g2_nor3_1 A B C Y VDD VSS
.ends

* Black-box entry subcircuit for sg13g2_dfrbpq_2 abstract view
.subckt sg13g2_dfrbpq_2 RESET_B VSS VDD D Q CLK
.ends

* Black-box entry subcircuit for sg13g2_tielo abstract view
.subckt sg13g2_tielo VDD VSS L_LO
.ends

* Black-box entry subcircuit for sg13g2_nand3_1 abstract view
.subckt sg13g2_nand3_1 B C A Y VDD VSS
.ends

* Black-box entry subcircuit for sg13g2_nor3_2 abstract view
.subckt sg13g2_nor3_2 A B C Y VDD VSS
.ends

* Black-box entry subcircuit for sg13g2_mux2_1 abstract view
.subckt sg13g2_mux2_1 A0 A1 S X VDD VSS
.ends

* Black-box entry subcircuit for sg13g2_inv_1 abstract view
.subckt sg13g2_inv_1 VDD Y A VSS
.ends

* Black-box entry subcircuit for sg13g2_inv_2 abstract view
.subckt sg13g2_inv_2 Y A VDD VSS
.ends

* Black-box entry subcircuit for sg13g2_a221oi_1 abstract view
.subckt sg13g2_a221oi_1 VDD VSS B2 C1 B1 A1 Y A2
.ends

* Black-box entry subcircuit for sg13g2_nand2b_1 abstract view
.subckt sg13g2_nand2b_1 Y B A_N VDD VSS
.ends

* Black-box entry subcircuit for sg13g2_nor2_2 abstract view
.subckt sg13g2_nor2_2 A B Y VDD VSS
.ends

* Black-box entry subcircuit for sg13g2_nor4_1 abstract view
.subckt sg13g2_nor4_1 A B C D Y VDD VSS
.ends

* Black-box entry subcircuit for sg13g2_buf_1 abstract view
.subckt sg13g2_buf_1 A X VDD VSS
.ends

* Black-box entry subcircuit for sg13g2_nand3b_1 abstract view
.subckt sg13g2_nand3b_1 B C Y VDD VSS A_N
.ends

* Black-box entry subcircuit for sg13g2_buf_2 abstract view
.subckt sg13g2_buf_2 A X VDD VSS
.ends

* Black-box entry subcircuit for sg13g2_or3_1 abstract view
.subckt sg13g2_or3_1 A B C X VDD VSS
.ends

* Black-box entry subcircuit for sg13g2_nor2b_2 abstract view
.subckt sg13g2_nor2b_2 A B_N Y VDD VSS
.ends

* Black-box entry subcircuit for sg13g2_and4_1 abstract view
.subckt sg13g2_and4_1 A B C D X VDD VSS
.ends

* Black-box entry subcircuit for sg13g2_a21oi_2 abstract view
.subckt sg13g2_a21oi_2 VSS VDD B1 Y A2 A1
.ends

* Black-box entry subcircuit for sg13g2_and3_1 abstract view
.subckt sg13g2_and3_1 X A B C VDD VSS
.ends

* Black-box entry subcircuit for sg13g2_or4_1 abstract view
.subckt sg13g2_or4_1 A B C D X VDD VSS
.ends

* Black-box entry subcircuit for sg13g2_nand2b_2 abstract view
.subckt sg13g2_nand2b_2 Y B VDD VSS A_N
.ends

* Black-box entry subcircuit for sg13g2_and3_2 abstract view
.subckt sg13g2_and3_2 X A B C VDD VSS
.ends

.subckt heichips25_template VGND VPWR clk ena rst_n ui_in[0] ui_in[1] ui_in[2] ui_in[3]
+ ui_in[4] ui_in[5] ui_in[6] ui_in[7] uio_in[0] uio_in[1] uio_in[2] uio_in[3] uio_in[4]
+ uio_in[5] uio_in[6] uio_in[7] uio_oe[0] uio_oe[1] uio_oe[2] uio_oe[3] uio_oe[4]
+ uio_oe[5] uio_oe[6] uio_oe[7] uio_out[0] uio_out[1] uio_out[2] uio_out[3] uio_out[4]
+ uio_out[5] uio_out[6] uio_out[7] uo_out[0] uo_out[1] uo_out[2] uo_out[3] uo_out[4]
+ uo_out[5] uo_out[6] uo_out[7]
XFILLER_39_222 VPWR VGND sg13g2_decap_8
X_2893__35 VPWR VGND net35 sg13g2_tiehi
X_2106_ net305 _0579_ _0580_ VPWR VGND sg13g2_and2_1
X_2037_ net335 net356 _0512_ VPWR VGND sg13g2_nor2b_1
XFILLER_36_951 VPWR VGND sg13g2_decap_8
XFILLER_23_656 VPWR VGND sg13g2_decap_8
XFILLER_35_494 VPWR VGND sg13g2_decap_4
X_2939_ net91 VGND VPWR _0096_ falutop.div_inst.b\[7\] clknet_4_3_0_clk sg13g2_dfrbpq_1
XFILLER_7_7 VPWR VGND sg13g2_decap_8
X_2884__46 VPWR VGND net46 sg13g2_tiehi
XFILLER_46_715 VPWR VGND sg13g2_decap_8
XFILLER_18_439 VPWR VGND sg13g2_fill_1
XFILLER_45_247 VPWR VGND sg13g2_decap_8
XFILLER_27_973 VPWR VGND sg13g2_decap_8
XFILLER_42_921 VPWR VGND sg13g2_decap_8
XFILLER_26_52 VPWR VGND sg13g2_decap_4
XFILLER_14_634 VPWR VGND sg13g2_decap_8
XFILLER_42_998 VPWR VGND sg13g2_decap_8
XFILLER_41_464 VPWR VGND sg13g2_fill_1
XFILLER_41_453 VPWR VGND sg13g2_fill_1
XFILLER_41_497 VPWR VGND sg13g2_decap_4
XFILLER_9_137 VPWR VGND sg13g2_fill_2
XFILLER_9_159 VPWR VGND sg13g2_decap_4
XFILLER_6_811 VPWR VGND sg13g2_decap_8
XFILLER_10_862 VPWR VGND sg13g2_decap_8
XFILLER_5_310 VPWR VGND sg13g2_decap_8
XFILLER_6_888 VPWR VGND sg13g2_decap_8
XFILLER_5_365 VPWR VGND sg13g2_fill_1
XFILLER_5_398 VPWR VGND sg13g2_decap_4
XFILLER_1_560 VPWR VGND sg13g2_decap_8
XFILLER_49_597 VPWR VGND sg13g2_decap_8
XFILLER_37_726 VPWR VGND sg13g2_fill_1
XFILLER_36_214 VPWR VGND sg13g2_decap_8
XFILLER_36_225 VPWR VGND sg13g2_fill_1
X_2890__38 VPWR VGND net38 sg13g2_tiehi
XFILLER_18_940 VPWR VGND sg13g2_decap_8
XFILLER_36_247 VPWR VGND sg13g2_decap_8
XFILLER_36_258 VPWR VGND sg13g2_fill_2
XFILLER_33_932 VPWR VGND sg13g2_decap_8
XFILLER_32_464 VPWR VGND sg13g2_decap_4
XFILLER_20_637 VPWR VGND sg13g2_decap_8
XFILLER_34_1020 VPWR VGND sg13g2_decap_8
XFILLER_8_170 VPWR VGND sg13g2_decap_8
XFILLER_9_693 VPWR VGND sg13g2_decap_8
X_2724_ _0749_ net325 net326 _1064_ VPWR VGND _0751_ sg13g2_nand4_1
X_2655_ _0995_ net377 _0993_ VPWR VGND sg13g2_nand2_2
X_1606_ _1289_ _0961_ _1290_ VPWR VGND sg13g2_xor2_1
X_2586_ VGND VPWR _0736_ net309 _0067_ _0937_ sg13g2_a21oi_1
X_1537_ _1222_ _0963_ _1071_ VPWR VGND sg13g2_nand2_1
XFILLER_41_1024 VPWR VGND sg13g2_decap_4
XFILLER_28_726 VPWR VGND sg13g2_decap_8
X_2866__68 VPWR VGND net68 sg13g2_tiehi
XFILLER_15_409 VPWR VGND sg13g2_decap_8
XFILLER_27_236 VPWR VGND sg13g2_decap_4
XFILLER_43_729 VPWR VGND sg13g2_decap_8
X_2881__49 VPWR VGND net49 sg13g2_tiehi
XFILLER_24_954 VPWR VGND sg13g2_decap_8
XFILLER_35_280 VPWR VGND sg13g2_decap_4
XFILLER_35_291 VPWR VGND sg13g2_decap_8
XFILLER_11_659 VPWR VGND sg13g2_decap_8
XFILLER_6_118 VPWR VGND sg13g2_decap_8
XFILLER_5_4 VPWR VGND sg13g2_decap_8
XFILLER_3_858 VPWR VGND sg13g2_decap_8
XFILLER_2_346 VPWR VGND sg13g2_decap_8
XFILLER_46_545 VPWR VGND sg13g2_decap_8
XFILLER_37_84 VPWR VGND sg13g2_decap_8
XFILLER_27_781 VPWR VGND sg13g2_decap_4
XFILLER_15_954 VPWR VGND sg13g2_decap_8
XFILLER_26_280 VPWR VGND sg13g2_decap_8
XFILLER_33_228 VPWR VGND sg13g2_decap_8
XFILLER_30_902 VPWR VGND sg13g2_decap_8
XFILLER_42_795 VPWR VGND sg13g2_decap_8
XFILLER_14_486 VPWR VGND sg13g2_fill_1
XFILLER_30_979 VPWR VGND sg13g2_decap_8
XFILLER_6_685 VPWR VGND sg13g2_decap_8
X_2440_ _0845_ VPWR _0846_ VGND net205 net283 sg13g2_o21ai_1
X_2371_ VGND VPWR net386 net175 _0787_ _0786_ sg13g2_a21oi_1
XFILLER_25_1008 VPWR VGND sg13g2_decap_8
XFILLER_49_372 VPWR VGND sg13g2_decap_8
XFILLER_37_534 VPWR VGND sg13g2_decap_8
XFILLER_37_567 VPWR VGND sg13g2_fill_2
XFILLER_37_556 VPWR VGND sg13g2_decap_8
XFILLER_37_545 VPWR VGND sg13g2_fill_1
XFILLER_21_946 VPWR VGND sg13g2_decap_8
XFILLER_33_795 VPWR VGND sg13g2_decap_8
XFILLER_20_456 VPWR VGND sg13g2_decap_4
Xclkbuf_4_12_0_clk clknet_0_clk clknet_4_12_0_clk VPWR VGND sg13g2_buf_8
XFILLER_9_490 VPWR VGND sg13g2_decap_8
X_2707_ VGND VPWR net308 _1039_ _1047_ _1045_ sg13g2_a21oi_1
X_2638_ _0977_ _0972_ _0971_ _0978_ VPWR VGND sg13g2_a21o_1
X_2569_ _0931_ _0774_ net246 net234 net386 VPWR VGND sg13g2_a22oi_1
XFILLER_0_806 VPWR VGND sg13g2_decap_8
XFILLER_47_309 VPWR VGND sg13g2_decap_8
XFILLER_28_512 VPWR VGND sg13g2_decap_4
XFILLER_28_534 VPWR VGND sg13g2_decap_8
XFILLER_15_217 VPWR VGND sg13g2_fill_2
XFILLER_28_589 VPWR VGND sg13g2_decap_8
XFILLER_43_537 VPWR VGND sg13g2_decap_8
XFILLER_24_773 VPWR VGND sg13g2_decap_8
XFILLER_11_412 VPWR VGND sg13g2_decap_8
XFILLER_11_423 VPWR VGND sg13g2_fill_2
XFILLER_8_928 VPWR VGND sg13g2_decap_8
XFILLER_12_968 VPWR VGND sg13g2_decap_8
XFILLER_23_64 VPWR VGND sg13g2_fill_2
XFILLER_11_489 VPWR VGND sg13g2_fill_1
XFILLER_3_655 VPWR VGND sg13g2_decap_8
XFILLER_2_132 VPWR VGND sg13g2_decap_8
XFILLER_48_61 VPWR VGND sg13g2_fill_2
XFILLER_47_854 VPWR VGND sg13g2_decap_8
XFILLER_0_35 VPWR VGND sg13g2_decap_8
XFILLER_19_545 VPWR VGND sg13g2_decap_8
XFILLER_34_548 VPWR VGND sg13g2_fill_1
X_2845__100 VPWR VGND net100 sg13g2_tiehi
X_1940_ _0415_ net327 _0417_ VPWR VGND sg13g2_xor2_1
XFILLER_30_721 VPWR VGND sg13g2_decap_8
XFILLER_9_77 VPWR VGND sg13g2_fill_2
XFILLER_30_765 VPWR VGND sg13g2_decap_4
X_1871_ _0349_ _0332_ _0350_ VPWR VGND sg13g2_xor2_1
XFILLER_7_961 VPWR VGND sg13g2_decap_8
XFILLER_6_482 VPWR VGND sg13g2_decap_8
X_2423_ _0832_ _0811_ _0812_ VPWR VGND sg13g2_xnor2_1
X_2354_ net387 _0771_ _0773_ VPWR VGND sg13g2_and2_1
XFILLER_38_810 VPWR VGND sg13g2_decap_8
X_2285_ net402 VPWR _0713_ VGND falutop.i2c_inst.data_in\[10\] _0712_ sg13g2_o21ai_1
XFILLER_49_191 VPWR VGND sg13g2_decap_8
XFILLER_38_876 VPWR VGND sg13g2_decap_8
XFILLER_25_537 VPWR VGND sg13g2_decap_8
XFILLER_33_581 VPWR VGND sg13g2_decap_8
XFILLER_20_242 VPWR VGND sg13g2_decap_4
XFILLER_21_754 VPWR VGND sg13g2_fill_2
XFILLER_4_419 VPWR VGND sg13g2_decap_8
XFILLER_0_603 VPWR VGND sg13g2_decap_8
XFILLER_28_342 VPWR VGND sg13g2_decap_8
XFILLER_44_802 VPWR VGND sg13g2_decap_8
XFILLER_16_504 VPWR VGND sg13g2_decap_8
XFILLER_43_312 VPWR VGND sg13g2_fill_1
XFILLER_16_537 VPWR VGND sg13g2_decap_8
XFILLER_28_386 VPWR VGND sg13g2_decap_8
XFILLER_44_879 VPWR VGND sg13g2_decap_8
XFILLER_43_389 VPWR VGND sg13g2_decap_8
XFILLER_12_765 VPWR VGND sg13g2_decap_8
XFILLER_24_592 VPWR VGND sg13g2_decap_8
XFILLER_8_725 VPWR VGND sg13g2_decap_8
XFILLER_4_986 VPWR VGND sg13g2_decap_8
XFILLER_3_452 VPWR VGND sg13g2_decap_8
XFILLER_38_128 VPWR VGND sg13g2_decap_8
X_2070_ net327 _0542_ _0544_ VPWR VGND sg13g2_and2_1
XFILLER_15_6 VPWR VGND sg13g2_fill_1
XFILLER_47_651 VPWR VGND sg13g2_fill_1
XFILLER_46_183 VPWR VGND sg13g2_decap_8
XFILLER_34_312 VPWR VGND sg13g2_fill_1
XFILLER_35_835 VPWR VGND sg13g2_fill_2
XFILLER_34_345 VPWR VGND sg13g2_decap_8
XFILLER_34_356 VPWR VGND sg13g2_fill_2
X_2972_ net131 VGND VPWR _0129_ falutop.i2c_inst.data_in\[1\] net395 sg13g2_dfrbpq_1
X_1923_ _0355_ _0398_ _0401_ VPWR VGND sg13g2_and2_1
XFILLER_30_584 VPWR VGND sg13g2_fill_1
X_1854_ _0281_ _0276_ _0280_ _0333_ VPWR VGND sg13g2_a21o_1
X_1785_ VGND VPWR _0265_ _0264_ _0263_ sg13g2_or2_1
X_2406_ _0816_ _0815_ _0805_ _0817_ VPWR VGND sg13g2_a21o_2
X_2337_ net421 _0756_ VPWR VGND sg13g2_inv_4
X_2268_ net408 VPWR _0701_ VGND falutop.i2c_inst.data_in\[5\] _0700_ sg13g2_o21ai_1
XFILLER_38_673 VPWR VGND sg13g2_decap_4
XFILLER_37_161 VPWR VGND sg13g2_fill_2
X_2199_ VGND VPWR net301 _0650_ _0114_ _0648_ sg13g2_a21oi_1
XFILLER_41_849 VPWR VGND sg13g2_decap_8
XFILLER_21_595 VPWR VGND sg13g2_decap_8
XFILLER_20_32 VPWR VGND sg13g2_fill_2
XFILLER_0_400 VPWR VGND sg13g2_decap_8
XFILLER_1_945 VPWR VGND sg13g2_decap_8
XFILLER_49_916 VPWR VGND sg13g2_decap_8
XFILLER_0_477 VPWR VGND sg13g2_decap_8
Xhold30 falutop.div_inst.a\[6\] VPWR VGND net204 sg13g2_dlygate4sd3_1
Xhold41 falutop.div_inst.val\[3\] VPWR VGND net215 sg13g2_dlygate4sd3_1
Xhold74 falutop.i2c_inst.result\[11\] VPWR VGND net248 sg13g2_dlygate4sd3_1
Xhold63 falutop.div_inst.val\[7\] VPWR VGND net237 sg13g2_dlygate4sd3_1
Xhold52 falutop.div_inst.val\[6\] VPWR VGND net226 sg13g2_dlygate4sd3_1
Xhold96 falutop.i2c_inst.result\[5\] VPWR VGND net270 sg13g2_dlygate4sd3_1
Xhold85 falutop.i2c_inst.result\[3\] VPWR VGND net259 sg13g2_dlygate4sd3_1
XFILLER_44_632 VPWR VGND sg13g2_decap_8
XFILLER_16_323 VPWR VGND sg13g2_fill_2
XFILLER_17_835 VPWR VGND sg13g2_decap_8
XFILLER_29_684 VPWR VGND sg13g2_decap_8
XFILLER_45_51 VPWR VGND sg13g2_fill_2
XFILLER_43_142 VPWR VGND sg13g2_decap_8
XFILLER_43_120 VPWR VGND sg13g2_fill_2
XFILLER_16_334 VPWR VGND sg13g2_decap_4
XFILLER_16_378 VPWR VGND sg13g2_fill_1
XFILLER_31_315 VPWR VGND sg13g2_decap_8
XFILLER_32_838 VPWR VGND sg13g2_decap_8
XFILLER_12_540 VPWR VGND sg13g2_decap_8
XFILLER_8_522 VPWR VGND sg13g2_decap_8
XFILLER_8_599 VPWR VGND sg13g2_decap_8
X_1570_ _1255_ _1236_ _1254_ VPWR VGND sg13g2_xnor2_1
XFILLER_4_783 VPWR VGND sg13g2_decap_8
XFILLER_3_271 VPWR VGND sg13g2_fill_1
XFILLER_20_4 VPWR VGND sg13g2_decap_8
X_2122_ _0543_ _0594_ _0595_ VPWR VGND sg13g2_nor2_1
XFILLER_26_109 VPWR VGND sg13g2_decap_8
X_2053_ _0499_ _0500_ _0527_ _0528_ VPWR VGND sg13g2_nor3_1
XFILLER_34_153 VPWR VGND sg13g2_fill_1
XFILLER_35_676 VPWR VGND sg13g2_fill_1
XFILLER_16_890 VPWR VGND sg13g2_decap_8
X_2955_ net31 VGND VPWR _0112_ falutop.alu_data_in\[15\] clknet_4_15_0_clk sg13g2_dfrbpq_1
X_2886_ net44 VGND VPWR _0043_ falutop.data_in\[15\] net394 sg13g2_dfrbpq_2
X_1906_ _0384_ _0381_ _0382_ VPWR VGND sg13g2_xnor2_1
X_1837_ VGND VPWR _0732_ _0315_ _0317_ net315 sg13g2_a21oi_1
X_1768_ VGND VPWR _0951_ _1126_ _0249_ _1032_ sg13g2_a21oi_1
X_1699_ VGND VPWR _0954_ _1119_ _0181_ _1096_ sg13g2_a21oi_1
Xheichips25_template_21 VPWR VGND uo_out[1] sg13g2_tielo
Xheichips25_template_10 VPWR VGND uio_oe[5] sg13g2_tielo
XFILLER_41_602 VPWR VGND sg13g2_decap_8
XFILLER_14_838 VPWR VGND sg13g2_decap_8
XFILLER_40_112 VPWR VGND sg13g2_decap_8
XFILLER_41_668 VPWR VGND sg13g2_decap_8
XFILLER_40_156 VPWR VGND sg13g2_decap_8
X_2906__166 VPWR VGND net166 sg13g2_tiehi
XFILLER_21_370 VPWR VGND sg13g2_fill_2
XFILLER_22_893 VPWR VGND sg13g2_decap_8
XFILLER_31_64 VPWR VGND sg13g2_decap_8
XFILLER_5_569 VPWR VGND sg13g2_decap_8
XFILLER_1_742 VPWR VGND sg13g2_decap_8
XFILLER_49_713 VPWR VGND sg13g2_decap_8
XFILLER_0_241 VPWR VGND sg13g2_decap_8
XFILLER_37_908 VPWR VGND sg13g2_decap_8
XFILLER_48_256 VPWR VGND sg13g2_decap_4
XFILLER_44_440 VPWR VGND sg13g2_decap_4
XFILLER_16_120 VPWR VGND sg13g2_fill_2
XFILLER_17_654 VPWR VGND sg13g2_fill_2
XFILLER_45_996 VPWR VGND sg13g2_decap_8
XFILLER_44_473 VPWR VGND sg13g2_fill_2
XFILLER_44_451 VPWR VGND sg13g2_decap_8
XFILLER_16_153 VPWR VGND sg13g2_decap_8
XFILLER_17_676 VPWR VGND sg13g2_decap_8
XFILLER_44_495 VPWR VGND sg13g2_decap_8
XFILLER_16_197 VPWR VGND sg13g2_decap_8
XFILLER_31_134 VPWR VGND sg13g2_decap_8
XFILLER_40_690 VPWR VGND sg13g2_fill_2
X_2740_ VGND VPWR net305 _1078_ _0079_ _1079_ sg13g2_a21oi_1
XFILLER_8_341 VPWR VGND sg13g2_fill_2
XFILLER_9_875 VPWR VGND sg13g2_decap_8
XFILLER_12_392 VPWR VGND sg13g2_decap_8
X_2671_ _1011_ _1001_ _1010_ VPWR VGND sg13g2_xnor2_1
XFILLER_8_385 VPWR VGND sg13g2_decap_8
X_1622_ VGND VPWR _0958_ _0999_ _1306_ _1305_ sg13g2_a21oi_1
X_1553_ _1238_ net346 net337 VPWR VGND sg13g2_nand2_1
XFILLER_4_580 VPWR VGND sg13g2_decap_8
Xfanout309 net310 net309 VPWR VGND sg13g2_buf_8
XFILLER_28_1028 VPWR VGND sg13g2_fill_1
XFILLER_39_201 VPWR VGND sg13g2_decap_8
XFILLER_39_245 VPWR VGND sg13g2_fill_2
XFILLER_27_407 VPWR VGND sg13g2_decap_4
XFILLER_39_289 VPWR VGND sg13g2_decap_8
XFILLER_36_930 VPWR VGND sg13g2_decap_8
X_2105_ _0577_ _0578_ net317 _0579_ VPWR VGND sg13g2_nand3_1
X_2036_ _0470_ VPWR _0511_ VGND _0468_ _0471_ sg13g2_o21ai_1
XFILLER_23_613 VPWR VGND sg13g2_fill_2
XFILLER_22_112 VPWR VGND sg13g2_fill_2
XFILLER_23_635 VPWR VGND sg13g2_decap_8
X_2938_ net102 VGND VPWR _0095_ falutop.div_inst.a\[7\] clknet_4_4_0_clk sg13g2_dfrbpq_1
X_2869_ net62 VGND VPWR _0026_ falutop.i2c_inst.counter\[4\] net396 sg13g2_dfrbpq_2
XFILLER_2_539 VPWR VGND sg13g2_decap_8
XFILLER_19_919 VPWR VGND sg13g2_decap_8
XFILLER_45_259 VPWR VGND sg13g2_fill_2
XFILLER_26_31 VPWR VGND sg13g2_decap_8
XFILLER_26_440 VPWR VGND sg13g2_decap_8
XFILLER_27_952 VPWR VGND sg13g2_decap_8
XFILLER_42_900 VPWR VGND sg13g2_decap_8
XFILLER_42_977 VPWR VGND sg13g2_decap_8
XFILLER_41_476 VPWR VGND sg13g2_decap_8
XFILLER_9_116 VPWR VGND sg13g2_decap_8
XFILLER_14_668 VPWR VGND sg13g2_fill_2
XFILLER_13_189 VPWR VGND sg13g2_decap_8
XFILLER_42_74 VPWR VGND sg13g2_decap_8
XFILLER_42_63 VPWR VGND sg13g2_fill_2
XFILLER_10_841 VPWR VGND sg13g2_decap_8
XFILLER_5_300 VPWR VGND sg13g2_decap_4
XFILLER_6_867 VPWR VGND sg13g2_decap_8
XFILLER_3_68 VPWR VGND sg13g2_decap_8
XFILLER_49_576 VPWR VGND sg13g2_decap_8
XFILLER_37_749 VPWR VGND sg13g2_decap_4
XFILLER_3_1019 VPWR VGND sg13g2_decap_8
XFILLER_17_440 VPWR VGND sg13g2_decap_8
XFILLER_18_996 VPWR VGND sg13g2_decap_8
XFILLER_33_911 VPWR VGND sg13g2_decap_8
XFILLER_45_793 VPWR VGND sg13g2_decap_8
XFILLER_44_281 VPWR VGND sg13g2_decap_8
XFILLER_44_270 VPWR VGND sg13g2_decap_4
XFILLER_20_605 VPWR VGND sg13g2_decap_8
XFILLER_33_988 VPWR VGND sg13g2_decap_8
X_2723_ _0749_ VPWR _1063_ VGND net325 net348 sg13g2_o21ai_1
XFILLER_9_672 VPWR VGND sg13g2_decap_8
X_2654_ net379 _0758_ _0992_ _0994_ VPWR VGND sg13g2_nor3_2
X_2953__40 VPWR VGND net40 sg13g2_tiehi
X_1605_ VGND VPWR _0966_ _1217_ _1289_ _0963_ sg13g2_a21oi_1
X_2585_ net400 VPWR _0937_ VGND net238 net310 sg13g2_o21ai_1
X_1536_ _0965_ _1046_ _1221_ VPWR VGND sg13g2_nor2_1
XFILLER_41_1003 VPWR VGND sg13g2_decap_8
XFILLER_43_708 VPWR VGND sg13g2_decap_8
X_2019_ _0495_ falutop.div_inst.rem\[3\] _0493_ VPWR VGND sg13g2_xnor2_1
XFILLER_24_933 VPWR VGND sg13g2_decap_8
XFILLER_10_104 VPWR VGND sg13g2_decap_8
XFILLER_11_638 VPWR VGND sg13g2_decap_8
XFILLER_10_148 VPWR VGND sg13g2_decap_4
X_2903__169 VPWR VGND net169 sg13g2_tiehi
XFILLER_3_837 VPWR VGND sg13g2_decap_8
XFILLER_19_749 VPWR VGND sg13g2_decap_8
XFILLER_37_63 VPWR VGND sg13g2_decap_8
XFILLER_27_760 VPWR VGND sg13g2_decap_8
XFILLER_34_719 VPWR VGND sg13g2_decap_8
XFILLER_15_933 VPWR VGND sg13g2_decap_8
X_2880__50 VPWR VGND net50 sg13g2_tiehi
XFILLER_42_774 VPWR VGND sg13g2_decap_4
XFILLER_42_752 VPWR VGND sg13g2_decap_4
XFILLER_41_251 VPWR VGND sg13g2_decap_4
XFILLER_30_958 VPWR VGND sg13g2_decap_8
XFILLER_6_664 VPWR VGND sg13g2_decap_8
XFILLER_5_185 VPWR VGND sg13g2_decap_8
X_2370_ _0736_ net385 _0786_ VPWR VGND sg13g2_nor2_1
XFILLER_25_708 VPWR VGND sg13g2_decap_8
XFILLER_37_579 VPWR VGND sg13g2_fill_1
XFILLER_24_218 VPWR VGND sg13g2_fill_2
XFILLER_33_752 VPWR VGND sg13g2_decap_8
XFILLER_33_774 VPWR VGND sg13g2_decap_8
XFILLER_21_925 VPWR VGND sg13g2_decap_8
X_2706_ _1046_ _0758_ _1030_ VPWR VGND sg13g2_nand2_2
X_2637_ _0976_ VPWR _0977_ VGND net326 net375 sg13g2_o21ai_1
X_2568_ net242 net239 _0773_ _0056_ VPWR VGND sg13g2_mux2_1
X_2499_ VGND VPWR net286 _0891_ _0025_ _0892_ sg13g2_a21oi_1
X_1519_ VPWR _1204_ _1203_ VGND sg13g2_inv_1
XFILLER_28_568 VPWR VGND sg13g2_decap_8
XFILLER_24_752 VPWR VGND sg13g2_decap_8
XFILLER_12_947 VPWR VGND sg13g2_decap_8
XFILLER_23_273 VPWR VGND sg13g2_decap_8
XFILLER_8_907 VPWR VGND sg13g2_decap_8
XFILLER_11_457 VPWR VGND sg13g2_decap_4
XFILLER_3_634 VPWR VGND sg13g2_decap_8
XFILLER_2_188 VPWR VGND sg13g2_decap_8
XFILLER_48_40 VPWR VGND sg13g2_decap_8
XFILLER_47_833 VPWR VGND sg13g2_decap_8
XFILLER_0_14 VPWR VGND sg13g2_decap_8
XFILLER_19_568 VPWR VGND sg13g2_decap_8
XFILLER_42_560 VPWR VGND sg13g2_decap_8
XFILLER_9_56 VPWR VGND sg13g2_decap_8
XFILLER_14_295 VPWR VGND sg13g2_decap_8
XFILLER_30_744 VPWR VGND sg13g2_decap_4
X_1870_ _0347_ _0333_ _0349_ VPWR VGND sg13g2_xor2_1
XFILLER_7_940 VPWR VGND sg13g2_decap_8
XFILLER_6_461 VPWR VGND sg13g2_decap_8
X_2422_ _0831_ net211 net289 VPWR VGND sg13g2_nand2_1
X_2353_ VPWR _0772_ _0771_ VGND sg13g2_inv_1
XFILLER_36_2 VPWR VGND sg13g2_fill_1
X_2284_ _0692_ _0707_ _0712_ VPWR VGND sg13g2_nor2_1
XFILLER_49_170 VPWR VGND sg13g2_decap_8
XFILLER_38_855 VPWR VGND sg13g2_decap_4
XFILLER_37_332 VPWR VGND sg13g2_fill_2
XFILLER_25_516 VPWR VGND sg13g2_decap_8
XFILLER_21_733 VPWR VGND sg13g2_decap_8
XFILLER_21_744 VPWR VGND sg13g2_fill_2
XFILLER_20_265 VPWR VGND sg13g2_fill_2
XFILLER_21_777 VPWR VGND sg13g2_fill_1
X_1999_ _0475_ _0467_ _0473_ VPWR VGND sg13g2_xnor2_1
XFILLER_20_287 VPWR VGND sg13g2_decap_8
XFILLER_0_659 VPWR VGND sg13g2_decap_8
XFILLER_47_107 VPWR VGND sg13g2_fill_1
XFILLER_29_833 VPWR VGND sg13g2_decap_8
XFILLER_29_888 VPWR VGND sg13g2_decap_8
XFILLER_44_858 VPWR VGND sg13g2_decap_8
XFILLER_8_704 VPWR VGND sg13g2_decap_8
XFILLER_12_744 VPWR VGND sg13g2_decap_8
XFILLER_34_86 VPWR VGND sg13g2_decap_8
XFILLER_11_298 VPWR VGND sg13g2_decap_4
XFILLER_4_965 VPWR VGND sg13g2_decap_8
XFILLER_3_431 VPWR VGND sg13g2_decap_8
XFILLER_39_608 VPWR VGND sg13g2_decap_8
X_2916__146 VPWR VGND net146 sg13g2_tiehi
XFILLER_22_8 VPWR VGND sg13g2_fill_2
XFILLER_46_140 VPWR VGND sg13g2_decap_8
Xclkbuf_4_11_0_clk clknet_0_clk clknet_4_11_0_clk VPWR VGND sg13g2_buf_8
XFILLER_46_162 VPWR VGND sg13g2_decap_8
XFILLER_19_398 VPWR VGND sg13g2_decap_4
X_2971_ net135 VGND VPWR _0128_ falutop.i2c_inst.data_in\[0\] net392 sg13g2_dfrbpq_1
X_2962__155 VPWR VGND net155 sg13g2_tiehi
X_1922_ VGND VPWR _0320_ _0355_ _0400_ _0399_ sg13g2_a21oi_1
X_1853_ _0332_ _0325_ _0331_ VPWR VGND sg13g2_xnor2_1
X_1784_ _0264_ net332 net374 VPWR VGND sg13g2_nand2_1
XFILLER_41_0 VPWR VGND sg13g2_decap_8
X_2405_ _0816_ falutop.div_inst.b1\[4\] falutop.div_inst.acc\[4\] VPWR VGND sg13g2_xnor2_1
X_2336_ _0755_ net328 VPWR VGND sg13g2_inv_2
XFILLER_29_107 VPWR VGND sg13g2_decap_4
X_2267_ _0689_ _0697_ _0700_ VPWR VGND sg13g2_nor2_1
XFILLER_29_129 VPWR VGND sg13g2_decap_8
XFILLER_26_803 VPWR VGND sg13g2_decap_4
X_2198_ _0649_ falutop.data_in\[1\] _0650_ VPWR VGND sg13g2_xor2_1
XFILLER_41_839 VPWR VGND sg13g2_decap_4
XFILLER_25_379 VPWR VGND sg13g2_decap_8
XFILLER_40_338 VPWR VGND sg13g2_decap_8
XFILLER_21_563 VPWR VGND sg13g2_fill_2
XFILLER_20_11 VPWR VGND sg13g2_decap_8
XFILLER_20_66 VPWR VGND sg13g2_decap_4
XFILLER_1_924 VPWR VGND sg13g2_decap_8
XFILLER_20_88 VPWR VGND sg13g2_decap_4
XFILLER_0_456 VPWR VGND sg13g2_decap_8
Xhold31 falutop.div_inst.acc\[5\] VPWR VGND net205 sg13g2_dlygate4sd3_1
Xhold20 _0001_ VPWR VGND net194 sg13g2_dlygate4sd3_1
Xhold42 falutop.div_inst.i\[0\] VPWR VGND net216 sg13g2_dlygate4sd3_1
Xhold53 falutop.div_inst.a\[0\] VPWR VGND net227 sg13g2_dlygate4sd3_1
Xhold64 falutop.div_inst.val\[4\] VPWR VGND net238 sg13g2_dlygate4sd3_1
XFILLER_29_630 VPWR VGND sg13g2_fill_1
Xhold75 _0090_ VPWR VGND net249 sg13g2_dlygate4sd3_1
Xhold86 falutop.div_inst.b1\[1\] VPWR VGND net260 sg13g2_dlygate4sd3_1
XFILLER_17_803 VPWR VGND sg13g2_fill_2
XFILLER_17_814 VPWR VGND sg13g2_decap_8
XFILLER_21_1023 VPWR VGND sg13g2_decap_4
Xhold97 falutop.i2c_inst.result\[13\] VPWR VGND net271 sg13g2_dlygate4sd3_1
XFILLER_44_611 VPWR VGND sg13g2_decap_8
XFILLER_44_699 VPWR VGND sg13g2_fill_2
XFILLER_32_828 VPWR VGND sg13g2_fill_2
XFILLER_8_501 VPWR VGND sg13g2_decap_8
XFILLER_12_563 VPWR VGND sg13g2_fill_1
XFILLER_8_578 VPWR VGND sg13g2_decap_8
XFILLER_6_46 VPWR VGND sg13g2_decap_8
XFILLER_4_762 VPWR VGND sg13g2_decap_8
XFILLER_6_1028 VPWR VGND sg13g2_fill_1
X_2121_ _0594_ _0583_ _0592_ VPWR VGND sg13g2_xnor2_1
X_2052_ _0527_ _0501_ _0525_ VPWR VGND sg13g2_xnor2_1
XFILLER_48_983 VPWR VGND sg13g2_decap_8
XFILLER_19_173 VPWR VGND sg13g2_decap_8
XFILLER_23_839 VPWR VGND sg13g2_decap_8
XFILLER_35_699 VPWR VGND sg13g2_decap_8
XFILLER_31_872 VPWR VGND sg13g2_fill_1
X_2954_ net33 VGND VPWR _0111_ falutop.alu_data_in\[14\] clknet_4_14_0_clk sg13g2_dfrbpq_2
X_2885_ net45 VGND VPWR _0042_ falutop.data_in\[14\] net392 sg13g2_dfrbpq_2
X_1905_ _0381_ _0382_ _0383_ VPWR VGND sg13g2_nor2b_1
X_1836_ VGND VPWR _0316_ _0315_ _0732_ sg13g2_or2_1
X_1767_ net358 _1071_ net334 _0248_ VPWR VGND sg13g2_nand3_1
X_1698_ VPWR VGND _0956_ _0179_ _1072_ _0953_ _0180_ _1051_ sg13g2_a221oi_1
XFILLER_44_1012 VPWR VGND sg13g2_decap_8
X_2319_ VPWR _0738_ net188 VGND sg13g2_inv_1
Xheichips25_template_11 VPWR VGND uio_oe[6] sg13g2_tielo
Xheichips25_template_22 VPWR VGND uo_out[2] sg13g2_tielo
XFILLER_39_994 VPWR VGND sg13g2_decap_8
XFILLER_38_482 VPWR VGND sg13g2_decap_8
XFILLER_14_817 VPWR VGND sg13g2_decap_8
XFILLER_25_154 VPWR VGND sg13g2_fill_1
XFILLER_40_135 VPWR VGND sg13g2_fill_1
XFILLER_15_99 VPWR VGND sg13g2_decap_8
XFILLER_22_872 VPWR VGND sg13g2_decap_8
XFILLER_31_43 VPWR VGND sg13g2_decap_8
XFILLER_5_548 VPWR VGND sg13g2_decap_8
XFILLER_0_220 VPWR VGND sg13g2_decap_8
XFILLER_1_721 VPWR VGND sg13g2_decap_8
XFILLER_1_798 VPWR VGND sg13g2_decap_8
XFILLER_49_769 VPWR VGND sg13g2_decap_8
XFILLER_16_132 VPWR VGND sg13g2_decap_8
XFILLER_45_975 VPWR VGND sg13g2_decap_8
XFILLER_32_603 VPWR VGND sg13g2_decap_8
XFILLER_16_176 VPWR VGND sg13g2_decap_8
XFILLER_31_113 VPWR VGND sg13g2_decap_8
XFILLER_32_647 VPWR VGND sg13g2_fill_1
XFILLER_9_854 VPWR VGND sg13g2_decap_8
XFILLER_12_371 VPWR VGND sg13g2_decap_8
X_2670_ _1008_ _0966_ _1010_ VPWR VGND sg13g2_xor2_1
X_1621_ _1305_ net363 net354 net376 net340 VPWR VGND sg13g2_a22oi_1
X_1552_ _1157_ VPWR _1237_ VGND _1147_ _1158_ sg13g2_o21ai_1
XFILLER_28_1007 VPWR VGND sg13g2_decap_8
X_2104_ falutop.div_inst.rem\[5\] _0535_ net382 _0578_ VPWR VGND sg13g2_nand3_1
XFILLER_28_909 VPWR VGND sg13g2_decap_8
XFILLER_48_780 VPWR VGND sg13g2_decap_8
X_2035_ _0510_ _0509_ VPWR VGND sg13g2_inv_2
XFILLER_36_986 VPWR VGND sg13g2_decap_8
X_2937_ net104 VGND VPWR net251 falutop.i2c_inst.result\[15\] clknet_4_13_0_clk sg13g2_dfrbpq_1
X_2868_ net64 VGND VPWR _0025_ falutop.i2c_inst.counter\[3\] net396 sg13g2_dfrbpq_2
X_2799_ net305 _1137_ net405 _1138_ VPWR VGND sg13g2_nand3_1
X_1819_ VGND VPWR _0234_ _0236_ _0299_ _0298_ sg13g2_a21oi_1
XFILLER_2_518 VPWR VGND sg13g2_decap_8
XFILLER_18_408 VPWR VGND sg13g2_decap_8
XFILLER_27_931 VPWR VGND sg13g2_decap_8
X_2982__125 VPWR VGND net125 sg13g2_tiehi
XFILLER_42_956 VPWR VGND sg13g2_decap_8
XFILLER_41_411 VPWR VGND sg13g2_fill_1
XFILLER_14_647 VPWR VGND sg13g2_fill_1
XFILLER_41_444 VPWR VGND sg13g2_decap_8
XFILLER_9_139 VPWR VGND sg13g2_fill_1
XFILLER_10_820 VPWR VGND sg13g2_decap_8
XFILLER_13_168 VPWR VGND sg13g2_decap_8
XFILLER_6_846 VPWR VGND sg13g2_decap_8
XFILLER_10_897 VPWR VGND sg13g2_decap_8
XFILLER_5_345 VPWR VGND sg13g2_decap_8
XFILLER_3_47 VPWR VGND sg13g2_decap_8
XFILLER_3_25 VPWR VGND sg13g2_decap_8
XFILLER_1_595 VPWR VGND sg13g2_decap_8
XFILLER_49_555 VPWR VGND sg13g2_decap_8
XFILLER_37_717 VPWR VGND sg13g2_decap_8
XFILLER_29_290 VPWR VGND sg13g2_decap_8
XFILLER_45_772 VPWR VGND sg13g2_decap_8
XFILLER_18_975 VPWR VGND sg13g2_decap_8
XFILLER_32_444 VPWR VGND sg13g2_fill_2
XFILLER_33_967 VPWR VGND sg13g2_decap_8
XFILLER_32_499 VPWR VGND sg13g2_decap_8
XFILLER_9_651 VPWR VGND sg13g2_decap_8
X_2722_ _1062_ _1040_ _1012_ VPWR VGND sg13g2_nand2b_1
X_2653_ net379 _0992_ _0993_ VPWR VGND sg13g2_nor2_1
X_2584_ VGND VPWR _0737_ net309 _0066_ _0936_ sg13g2_a21oi_1
X_1604_ _0980_ _1043_ _1288_ VPWR VGND sg13g2_and2_1
X_1535_ _1220_ _1219_ _1023_ _1126_ _0966_ VPWR VGND sg13g2_a22oi_1
XFILLER_28_717 VPWR VGND sg13g2_fill_2
XFILLER_27_249 VPWR VGND sg13g2_decap_8
X_2018_ _0494_ _0493_ falutop.div_inst.rem\[3\] VPWR VGND sg13g2_nand2b_1
XFILLER_24_912 VPWR VGND sg13g2_decap_8
XFILLER_36_761 VPWR VGND sg13g2_decap_4
XFILLER_23_444 VPWR VGND sg13g2_fill_2
XFILLER_23_455 VPWR VGND sg13g2_fill_1
XFILLER_24_989 VPWR VGND sg13g2_decap_8
XFILLER_11_617 VPWR VGND sg13g2_decap_8
XFILLER_12_34 VPWR VGND sg13g2_decap_4
XFILLER_3_816 VPWR VGND sg13g2_decap_8
XFILLER_2_304 VPWR VGND sg13g2_fill_1
XFILLER_18_205 VPWR VGND sg13g2_fill_2
X_2865__70 VPWR VGND net70 sg13g2_tiehi
XFILLER_15_912 VPWR VGND sg13g2_decap_8
XFILLER_14_444 VPWR VGND sg13g2_decap_4
XFILLER_15_989 VPWR VGND sg13g2_decap_8
XFILLER_18_1017 VPWR VGND sg13g2_decap_8
XFILLER_18_1028 VPWR VGND sg13g2_fill_1
XFILLER_14_477 VPWR VGND sg13g2_decap_8
XFILLER_30_937 VPWR VGND sg13g2_decap_8
XFILLER_41_285 VPWR VGND sg13g2_decap_8
XFILLER_6_643 VPWR VGND sg13g2_decap_8
XFILLER_10_694 VPWR VGND sg13g2_decap_8
XFILLER_5_164 VPWR VGND sg13g2_decap_8
XFILLER_5_153 VPWR VGND sg13g2_fill_2
XFILLER_5_142 VPWR VGND sg13g2_decap_8
XFILLER_2_882 VPWR VGND sg13g2_decap_8
XFILLER_1_392 VPWR VGND sg13g2_decap_8
XFILLER_37_514 VPWR VGND sg13g2_fill_2
XFILLER_18_750 VPWR VGND sg13g2_decap_8
XFILLER_45_580 VPWR VGND sg13g2_fill_2
XFILLER_21_904 VPWR VGND sg13g2_decap_8
X_2926__126 VPWR VGND net126 sg13g2_tiehi
XFILLER_20_425 VPWR VGND sg13g2_decap_4
XFILLER_32_296 VPWR VGND sg13g2_decap_8
X_2705_ net378 net377 _1013_ _1045_ VPWR VGND sg13g2_nor3_2
X_2902__170 VPWR VGND net170 sg13g2_tiehi
X_2636_ VGND VPWR _0976_ _0975_ _0973_ sg13g2_or2_1
X_2567_ net260 net229 _0773_ _0055_ VPWR VGND sg13g2_mux2_1
X_2498_ net403 VPWR _0892_ VGND falutop.i2c_inst.counter\[3\] net286 sg13g2_o21ai_1
X_1518_ _1203_ _1202_ _1164_ VPWR VGND sg13g2_nand2b_1
XFILLER_15_219 VPWR VGND sg13g2_fill_1
XFILLER_24_731 VPWR VGND sg13g2_decap_8
XFILLER_12_926 VPWR VGND sg13g2_decap_8
XFILLER_23_11 VPWR VGND sg13g2_fill_1
XFILLER_23_252 VPWR VGND sg13g2_decap_8
XFILLER_11_436 VPWR VGND sg13g2_decap_8
XFILLER_7_429 VPWR VGND sg13g2_decap_8
XFILLER_20_992 VPWR VGND sg13g2_decap_8
XFILLER_3_613 VPWR VGND sg13g2_decap_8
XFILLER_2_167 VPWR VGND sg13g2_decap_8
XFILLER_24_1010 VPWR VGND sg13g2_decap_8
XFILLER_47_812 VPWR VGND sg13g2_decap_8
XFILLER_47_889 VPWR VGND sg13g2_decap_8
XFILLER_46_366 VPWR VGND sg13g2_decap_8
XFILLER_34_506 VPWR VGND sg13g2_decap_4
XFILLER_46_388 VPWR VGND sg13g2_decap_8
XFILLER_34_528 VPWR VGND sg13g2_decap_8
XFILLER_15_753 VPWR VGND sg13g2_decap_8
XFILLER_42_583 VPWR VGND sg13g2_decap_8
XFILLER_9_35 VPWR VGND sg13g2_decap_8
XFILLER_14_263 VPWR VGND sg13g2_decap_8
XFILLER_15_786 VPWR VGND sg13g2_decap_8
XFILLER_9_79 VPWR VGND sg13g2_fill_1
XFILLER_30_789 VPWR VGND sg13g2_decap_8
XFILLER_11_981 VPWR VGND sg13g2_decap_8
XFILLER_31_1025 VPWR VGND sg13g2_decap_4
XFILLER_7_996 VPWR VGND sg13g2_decap_8
X_2421_ _0827_ VPWR _0009_ VGND _0768_ _0830_ sg13g2_o21ai_1
X_2352_ _0771_ _0769_ _0770_ VPWR VGND sg13g2_nand2_1
XFILLER_9_1015 VPWR VGND sg13g2_decap_8
X_2283_ VGND VPWR net389 _0710_ _0137_ _0711_ sg13g2_a21oi_1
XFILLER_38_834 VPWR VGND sg13g2_decap_8
XFILLER_18_580 VPWR VGND sg13g2_fill_1
XFILLER_33_572 VPWR VGND sg13g2_fill_2
X_1998_ _0474_ _0467_ _0473_ VPWR VGND sg13g2_nand2_1
X_2619_ _0959_ net339 net365 VPWR VGND sg13g2_nand2_1
XFILLER_0_638 VPWR VGND sg13g2_decap_8
XFILLER_47_119 VPWR VGND sg13g2_decap_8
XFILLER_44_837 VPWR VGND sg13g2_decap_8
XFILLER_34_21 VPWR VGND sg13g2_decap_8
XFILLER_12_701 VPWR VGND sg13g2_decap_8
XFILLER_24_561 VPWR VGND sg13g2_decap_8
XFILLER_24_572 VPWR VGND sg13g2_fill_2
XFILLER_11_200 VPWR VGND sg13g2_decap_8
XFILLER_34_65 VPWR VGND sg13g2_decap_8
XFILLER_11_233 VPWR VGND sg13g2_decap_8
XFILLER_11_266 VPWR VGND sg13g2_fill_2
XFILLER_11_277 VPWR VGND sg13g2_decap_8
XFILLER_4_944 VPWR VGND sg13g2_decap_8
XFILLER_3_410 VPWR VGND sg13g2_decap_8
XFILLER_3_487 VPWR VGND sg13g2_decap_8
XFILLER_1_0 VPWR VGND sg13g2_decap_8
XFILLER_47_631 VPWR VGND sg13g2_fill_2
Xfanout290 _1140_ net290 VPWR VGND sg13g2_buf_8
XFILLER_19_344 VPWR VGND sg13g2_decap_8
XFILLER_47_686 VPWR VGND sg13g2_decap_8
XFILLER_35_859 VPWR VGND sg13g2_decap_8
X_2970_ net139 VGND VPWR _0127_ falutop.i2c_inst.data_in\[19\] net398 sg13g2_dfrbpq_1
XFILLER_43_892 VPWR VGND sg13g2_decap_8
XFILLER_30_531 VPWR VGND sg13g2_decap_8
X_1921_ VGND VPWR _0399_ _0398_ _0354_ sg13g2_or2_1
XFILLER_30_542 VPWR VGND sg13g2_fill_1
X_1852_ _0331_ _0326_ _0329_ VPWR VGND sg13g2_xnor2_1
XFILLER_30_575 VPWR VGND sg13g2_decap_8
X_1783_ _0263_ net330 net376 VPWR VGND sg13g2_nand2_2
XFILLER_7_793 VPWR VGND sg13g2_decap_8
X_2404_ _0814_ _0813_ _0806_ _0815_ VPWR VGND sg13g2_a21o_1
XFILLER_34_0 VPWR VGND sg13g2_decap_8
X_2335_ VPWR _0754_ net334 VGND sg13g2_inv_1
X_2266_ VGND VPWR net391 _0698_ _0132_ _0699_ sg13g2_a21oi_1
XFILLER_38_664 VPWR VGND sg13g2_fill_1
X_2197_ _0649_ net384 falutop.data_in\[0\] VPWR VGND sg13g2_nand2_1
XFILLER_37_163 VPWR VGND sg13g2_fill_1
XFILLER_26_848 VPWR VGND sg13g2_fill_1
XFILLER_38_1009 VPWR VGND sg13g2_decap_8
XFILLER_37_196 VPWR VGND sg13g2_decap_8
XFILLER_25_358 VPWR VGND sg13g2_decap_8
XFILLER_34_870 VPWR VGND sg13g2_decap_4
XFILLER_21_542 VPWR VGND sg13g2_fill_1
XFILLER_14_1020 VPWR VGND sg13g2_decap_8
XFILLER_20_34 VPWR VGND sg13g2_fill_1
XFILLER_1_903 VPWR VGND sg13g2_decap_8
XFILLER_0_435 VPWR VGND sg13g2_decap_8
Xhold32 _0012_ VPWR VGND net206 sg13g2_dlygate4sd3_1
Xhold21 falutop.div_inst.done VPWR VGND net195 sg13g2_dlygate4sd3_1
Xhold10 falutop.div_inst.a\[4\] VPWR VGND net184 sg13g2_dlygate4sd3_1
XFILLER_29_32 VPWR VGND sg13g2_decap_8
Xhold43 _0926_ VPWR VGND net217 sg13g2_dlygate4sd3_1
Xhold54 falutop.div_inst.b\[4\] VPWR VGND net228 sg13g2_dlygate4sd3_1
Xhold65 falutop.div_inst.b\[2\] VPWR VGND net239 sg13g2_dlygate4sd3_1
XFILLER_21_1002 VPWR VGND sg13g2_decap_8
Xhold87 falutop.i2c_inst.result\[14\] VPWR VGND net261 sg13g2_dlygate4sd3_1
Xhold98 _0092_ VPWR VGND net272 sg13g2_dlygate4sd3_1
Xhold76 falutop.i2c_inst.result\[15\] VPWR VGND net250 sg13g2_dlygate4sd3_1
XFILLER_45_31 VPWR VGND sg13g2_fill_2
XFILLER_28_163 VPWR VGND sg13g2_fill_1
XFILLER_45_64 VPWR VGND sg13g2_fill_2
XFILLER_44_678 VPWR VGND sg13g2_decap_8
XFILLER_43_177 VPWR VGND sg13g2_decap_8
XFILLER_32_818 VPWR VGND sg13g2_fill_2
XFILLER_43_188 VPWR VGND sg13g2_fill_1
XFILLER_31_339 VPWR VGND sg13g2_decap_8
XFILLER_40_851 VPWR VGND sg13g2_decap_8
XFILLER_40_840 VPWR VGND sg13g2_fill_2
XFILLER_40_884 VPWR VGND sg13g2_decap_8
XFILLER_12_575 VPWR VGND sg13g2_decap_8
XFILLER_8_557 VPWR VGND sg13g2_decap_8
XFILLER_6_25 VPWR VGND sg13g2_decap_8
XFILLER_4_741 VPWR VGND sg13g2_decap_8
XFILLER_3_295 VPWR VGND sg13g2_decap_8
XFILLER_39_417 VPWR VGND sg13g2_fill_2
XFILLER_39_406 VPWR VGND sg13g2_fill_2
XFILLER_6_1007 VPWR VGND sg13g2_decap_8
X_2120_ _0583_ _0592_ _0593_ VPWR VGND sg13g2_nor2_1
XFILLER_48_962 VPWR VGND sg13g2_decap_8
X_2051_ _0526_ _0501_ _0525_ VPWR VGND sg13g2_nand2_1
XFILLER_19_130 VPWR VGND sg13g2_decap_8
XFILLER_47_483 VPWR VGND sg13g2_decap_8
XFILLER_19_152 VPWR VGND sg13g2_decap_8
XFILLER_34_100 VPWR VGND sg13g2_decap_8
XFILLER_34_111 VPWR VGND sg13g2_fill_1
XFILLER_23_818 VPWR VGND sg13g2_decap_8
XFILLER_35_689 VPWR VGND sg13g2_decap_4
X_2953_ net40 VGND VPWR _0110_ falutop.alu_data_in\[13\] clknet_4_14_0_clk sg13g2_dfrbpq_1
XFILLER_37_1020 VPWR VGND sg13g2_decap_8
XFILLER_34_188 VPWR VGND sg13g2_decap_8
X_1904_ net347 net356 _0382_ VPWR VGND sg13g2_nor2b_1
X_2884_ net46 VGND VPWR _0041_ falutop.data_in\[13\] net393 sg13g2_dfrbpq_2
XFILLER_30_361 VPWR VGND sg13g2_decap_4
XFILLER_30_383 VPWR VGND sg13g2_fill_1
X_1835_ net318 VPWR _0315_ VGND falutop.div_inst.val\[6\] _0186_ sg13g2_o21ai_1
X_1766_ _0245_ VPWR _0247_ VGND _0756_ _0246_ sg13g2_o21ai_1
XFILLER_7_590 VPWR VGND sg13g2_decap_8
X_1697_ _0954_ _1046_ _0179_ VPWR VGND sg13g2_nor2_1
X_2318_ VPWR _0737_ net193 VGND sg13g2_inv_1
Xheichips25_template_12 VPWR VGND uio_oe[7] sg13g2_tielo
XFILLER_39_973 VPWR VGND sg13g2_decap_8
Xheichips25_template_23 VPWR VGND uo_out[3] sg13g2_tielo
X_2249_ VGND VPWR net391 _0686_ _0127_ _0687_ sg13g2_a21oi_1
XFILLER_38_450 VPWR VGND sg13g2_decap_4
XFILLER_26_612 VPWR VGND sg13g2_decap_4
XFILLER_25_122 VPWR VGND sg13g2_fill_1
XFILLER_26_645 VPWR VGND sg13g2_decap_8
XFILLER_26_656 VPWR VGND sg13g2_fill_1
XFILLER_41_648 VPWR VGND sg13g2_decap_4
XFILLER_13_328 VPWR VGND sg13g2_fill_2
XFILLER_15_34 VPWR VGND sg13g2_decap_8
XFILLER_22_851 VPWR VGND sg13g2_decap_8
XFILLER_31_22 VPWR VGND sg13g2_decap_8
XFILLER_5_527 VPWR VGND sg13g2_decap_8
Xclkbuf_4_10_0_clk clknet_0_clk clknet_4_10_0_clk VPWR VGND sg13g2_buf_8
XFILLER_31_99 VPWR VGND sg13g2_decap_8
XFILLER_1_700 VPWR VGND sg13g2_decap_8
XFILLER_1_777 VPWR VGND sg13g2_decap_8
XFILLER_49_748 VPWR VGND sg13g2_decap_8
XFILLER_0_298 VPWR VGND sg13g2_decap_8
XFILLER_17_601 VPWR VGND sg13g2_decap_4
XFILLER_45_954 VPWR VGND sg13g2_decap_8
XFILLER_32_626 VPWR VGND sg13g2_decap_8
XFILLER_9_833 VPWR VGND sg13g2_decap_8
XFILLER_13_884 VPWR VGND sg13g2_decap_8
XFILLER_31_169 VPWR VGND sg13g2_decap_4
X_1620_ _0959_ _1000_ _1304_ VPWR VGND sg13g2_nor2_2
X_1551_ _1236_ net343 net341 VPWR VGND sg13g2_nand2_1
XFILLER_39_247 VPWR VGND sg13g2_fill_1
X_2103_ _0535_ net382 falutop.div_inst.rem\[5\] _0577_ VPWR VGND sg13g2_a21o_1
X_2034_ _0509_ _0263_ _0508_ VPWR VGND sg13g2_xnor2_1
XFILLER_36_965 VPWR VGND sg13g2_decap_8
XFILLER_35_442 VPWR VGND sg13g2_decap_8
XFILLER_35_464 VPWR VGND sg13g2_decap_4
XFILLER_22_147 VPWR VGND sg13g2_fill_2
X_2936_ net106 VGND VPWR net262 falutop.i2c_inst.result\[14\] clknet_4_13_0_clk sg13g2_dfrbpq_1
X_2867_ net66 VGND VPWR _0024_ falutop.i2c_inst.counter\[2\] net397 sg13g2_dfrbpq_2
XFILLER_11_1023 VPWR VGND sg13g2_decap_4
X_1818_ _0298_ net357 _0296_ VPWR VGND sg13g2_xnor2_1
X_2798_ _1136_ VPWR _1137_ VGND falutop.div_inst.val\[1\] _1135_ sg13g2_o21ai_1
X_2936__106 VPWR VGND net106 sg13g2_tiehi
X_1749_ net329 net343 _0228_ _0230_ VPWR VGND sg13g2_a21o_1
XFILLER_46_729 VPWR VGND sg13g2_decap_8
XFILLER_45_217 VPWR VGND sg13g2_decap_8
XFILLER_27_910 VPWR VGND sg13g2_decap_8
XFILLER_45_228 VPWR VGND sg13g2_fill_1
XFILLER_38_291 VPWR VGND sg13g2_decap_8
XFILLER_26_11 VPWR VGND sg13g2_decap_8
XFILLER_26_66 VPWR VGND sg13g2_decap_8
XFILLER_27_987 VPWR VGND sg13g2_decap_8
XFILLER_42_935 VPWR VGND sg13g2_decap_8
XFILLER_41_423 VPWR VGND sg13g2_decap_8
XFILLER_13_114 VPWR VGND sg13g2_decap_8
XFILLER_6_825 VPWR VGND sg13g2_decap_8
XFILLER_10_876 VPWR VGND sg13g2_decap_8
XFILLER_5_324 VPWR VGND sg13g2_decap_8
XFILLER_49_512 VPWR VGND sg13g2_decap_8
XFILLER_1_574 VPWR VGND sg13g2_decap_8
XFILLER_49_534 VPWR VGND sg13g2_decap_8
XFILLER_18_954 VPWR VGND sg13g2_decap_8
XFILLER_36_239 VPWR VGND sg13g2_fill_2
XFILLER_45_751 VPWR VGND sg13g2_decap_8
XFILLER_44_250 VPWR VGND sg13g2_decap_8
XFILLER_32_412 VPWR VGND sg13g2_decap_8
XFILLER_32_423 VPWR VGND sg13g2_decap_8
XFILLER_33_946 VPWR VGND sg13g2_decap_8
XFILLER_32_478 VPWR VGND sg13g2_decap_8
XFILLER_9_630 VPWR VGND sg13g2_decap_8
X_2721_ _1060_ VPWR _1061_ VGND net345 _1058_ sg13g2_o21ai_1
XFILLER_8_184 VPWR VGND sg13g2_decap_8
X_2652_ _0992_ net380 _0756_ VPWR VGND sg13g2_nand2_2
X_2583_ net404 VPWR _0936_ VGND net215 net309 sg13g2_o21ai_1
X_1603_ _0962_ _0979_ _0961_ _1287_ VPWR VGND sg13g2_nand3_1
XFILLER_5_891 VPWR VGND sg13g2_decap_8
X_1534_ _1055_ _1064_ _1219_ VPWR VGND sg13g2_nor2_1
X_2017_ _0453_ _0492_ _0493_ VPWR VGND sg13g2_and2_1
XFILLER_23_423 VPWR VGND sg13g2_decap_8
XFILLER_36_784 VPWR VGND sg13g2_decap_8
XFILLER_24_968 VPWR VGND sg13g2_decap_8
XFILLER_23_467 VPWR VGND sg13g2_fill_1
X_2919_ net140 VGND VPWR _0076_ falutop.div_inst.rem\[5\] clknet_4_9_0_clk sg13g2_dfrbpq_1
XFILLER_12_13 VPWR VGND sg13g2_decap_8
XFILLER_12_57 VPWR VGND sg13g2_decap_8
XFILLER_2_327 VPWR VGND sg13g2_fill_2
XFILLER_46_515 VPWR VGND sg13g2_decap_8
XFILLER_37_32 VPWR VGND sg13g2_fill_2
XFILLER_37_21 VPWR VGND sg13g2_decap_8
XFILLER_19_707 VPWR VGND sg13g2_decap_8
XFILLER_19_729 VPWR VGND sg13g2_decap_8
XFILLER_46_526 VPWR VGND sg13g2_fill_1
XFILLER_15_968 VPWR VGND sg13g2_decap_8
XFILLER_26_294 VPWR VGND sg13g2_decap_8
XFILLER_30_916 VPWR VGND sg13g2_decap_8
XFILLER_6_622 VPWR VGND sg13g2_decap_8
XFILLER_10_673 VPWR VGND sg13g2_decap_8
XFILLER_6_699 VPWR VGND sg13g2_decap_8
XFILLER_2_861 VPWR VGND sg13g2_decap_8
XFILLER_38_7 VPWR VGND sg13g2_fill_2
XFILLER_1_371 VPWR VGND sg13g2_decap_8
XFILLER_49_353 VPWR VGND sg13g2_fill_1
XFILLER_49_386 VPWR VGND sg13g2_decap_8
XFILLER_17_261 VPWR VGND sg13g2_fill_1
XFILLER_18_784 VPWR VGND sg13g2_decap_8
XFILLER_32_253 VPWR VGND sg13g2_decap_4
XFILLER_32_275 VPWR VGND sg13g2_decap_8
X_2704_ _1000_ VPWR _1044_ VGND _1041_ _1043_ sg13g2_o21ai_1
X_2635_ net351 net372 _0975_ VPWR VGND sg13g2_nor2_2
X_2566_ VPWR _0054_ net244 VGND sg13g2_inv_1
X_2497_ VGND VPWR net2 _0871_ _0891_ _0890_ sg13g2_a21oi_1
X_1517_ _1200_ _1201_ _1202_ VPWR VGND sg13g2_nor2_1
XFILLER_24_710 VPWR VGND sg13g2_decap_8
XFILLER_12_905 VPWR VGND sg13g2_decap_8
XFILLER_23_231 VPWR VGND sg13g2_decap_8
XFILLER_24_787 VPWR VGND sg13g2_decap_8
XFILLER_23_23 VPWR VGND sg13g2_decap_8
XFILLER_23_297 VPWR VGND sg13g2_fill_2
XFILLER_20_971 VPWR VGND sg13g2_decap_8
XFILLER_23_89 VPWR VGND sg13g2_decap_8
XFILLER_3_669 VPWR VGND sg13g2_decap_8
XFILLER_3_4 VPWR VGND sg13g2_decap_8
XFILLER_2_146 VPWR VGND sg13g2_fill_1
XFILLER_19_504 VPWR VGND sg13g2_decap_8
XFILLER_46_312 VPWR VGND sg13g2_fill_1
XFILLER_46_301 VPWR VGND sg13g2_decap_8
XFILLER_47_868 VPWR VGND sg13g2_decap_8
XFILLER_0_49 VPWR VGND sg13g2_decap_8
XFILLER_15_721 VPWR VGND sg13g2_decap_8
XFILLER_27_592 VPWR VGND sg13g2_decap_8
XFILLER_9_14 VPWR VGND sg13g2_decap_8
XFILLER_30_735 VPWR VGND sg13g2_decap_4
XFILLER_11_960 VPWR VGND sg13g2_decap_8
XFILLER_31_1004 VPWR VGND sg13g2_decap_8
XFILLER_10_470 VPWR VGND sg13g2_decap_8
XFILLER_7_975 VPWR VGND sg13g2_decap_8
XFILLER_6_496 VPWR VGND sg13g2_decap_8
X_2420_ _0829_ VPWR _0830_ VGND net209 net282 sg13g2_o21ai_1
X_2351_ net229 net263 net234 net239 _0770_ VPWR VGND sg13g2_nor4_1
X_2282_ net402 VPWR _0711_ VGND falutop.i2c_inst.data_in\[9\] _0710_ sg13g2_o21ai_1
XFILLER_38_824 VPWR VGND sg13g2_decap_4
XFILLER_46_890 VPWR VGND sg13g2_decap_8
XFILLER_21_702 VPWR VGND sg13g2_fill_2
XFILLER_20_212 VPWR VGND sg13g2_decap_8
XFILLER_33_595 VPWR VGND sg13g2_fill_2
X_1997_ _0473_ _0468_ _0472_ VPWR VGND sg13g2_xnor2_1
XFILLER_20_267 VPWR VGND sg13g2_fill_1
XFILLER_47_1022 VPWR VGND sg13g2_decap_8
X_2618_ net341 net364 _0958_ VPWR VGND sg13g2_and2_1
XFILLER_0_617 VPWR VGND sg13g2_decap_8
X_2549_ VGND VPWR net387 _0772_ _0922_ net311 sg13g2_a21oi_1
XFILLER_44_816 VPWR VGND sg13g2_decap_8
XFILLER_18_56 VPWR VGND sg13g2_decap_8
XFILLER_28_356 VPWR VGND sg13g2_fill_2
XFILLER_16_518 VPWR VGND sg13g2_decap_8
XFILLER_43_359 VPWR VGND sg13g2_decap_8
XFILLER_43_348 VPWR VGND sg13g2_decap_4
XFILLER_34_44 VPWR VGND sg13g2_decap_8
XFILLER_11_256 VPWR VGND sg13g2_decap_4
XFILLER_12_779 VPWR VGND sg13g2_decap_8
XFILLER_8_739 VPWR VGND sg13g2_decap_8
XFILLER_4_923 VPWR VGND sg13g2_decap_8
XFILLER_3_466 VPWR VGND sg13g2_decap_8
XFILLER_19_323 VPWR VGND sg13g2_decap_8
Xfanout280 net281 net280 VPWR VGND sg13g2_buf_8
Xfanout291 _1140_ net291 VPWR VGND sg13g2_buf_1
XFILLER_46_120 VPWR VGND sg13g2_decap_8
XFILLER_35_816 VPWR VGND sg13g2_decap_4
XFILLER_46_197 VPWR VGND sg13g2_decap_8
XFILLER_43_871 VPWR VGND sg13g2_decap_8
XFILLER_15_562 VPWR VGND sg13g2_decap_8
X_1920_ _0396_ _0395_ _0398_ VPWR VGND sg13g2_xor2_1
XFILLER_30_510 VPWR VGND sg13g2_decap_8
XFILLER_30_554 VPWR VGND sg13g2_decap_8
X_1851_ _0330_ _0326_ _0329_ VPWR VGND sg13g2_nand2_1
X_1782_ net323 _0759_ _0262_ VPWR VGND sg13g2_nor2_2
XFILLER_7_772 VPWR VGND sg13g2_decap_8
XFILLER_6_293 VPWR VGND sg13g2_fill_1
XFILLER_6_282 VPWR VGND sg13g2_decap_8
X_2403_ _0814_ falutop.div_inst.b1\[3\] falutop.div_inst.acc\[3\] VPWR VGND sg13g2_xnor2_1
X_2334_ net339 _0753_ VPWR VGND sg13g2_inv_4
XFILLER_27_0 VPWR VGND sg13g2_decap_8
X_2265_ net408 VPWR _0699_ VGND falutop.i2c_inst.data_in\[4\] _0698_ sg13g2_o21ai_1
XFILLER_38_643 VPWR VGND sg13g2_fill_1
XFILLER_37_142 VPWR VGND sg13g2_fill_1
XFILLER_37_120 VPWR VGND sg13g2_decap_8
X_2196_ net229 net302 _0648_ VPWR VGND sg13g2_nor2_1
XFILLER_38_698 VPWR VGND sg13g2_decap_8
XFILLER_37_175 VPWR VGND sg13g2_decap_8
XFILLER_25_315 VPWR VGND sg13g2_decap_8
XFILLER_26_827 VPWR VGND sg13g2_decap_8
XFILLER_33_381 VPWR VGND sg13g2_decap_4
XFILLER_33_392 VPWR VGND sg13g2_decap_8
XFILLER_5_709 VPWR VGND sg13g2_decap_8
XFILLER_0_414 VPWR VGND sg13g2_decap_8
XFILLER_1_959 VPWR VGND sg13g2_decap_8
XFILLER_29_11 VPWR VGND sg13g2_decap_8
Xhold11 falutop.div_inst.b\[6\] VPWR VGND net185 sg13g2_dlygate4sd3_1
Xhold22 falutop.div_inst.quo\[6\] VPWR VGND net196 sg13g2_dlygate4sd3_1
Xhold55 falutop.div_inst.b\[1\] VPWR VGND net229 sg13g2_dlygate4sd3_1
Xhold44 _0051_ VPWR VGND net218 sg13g2_dlygate4sd3_1
Xhold33 falutop.div_inst.acc\[6\] VPWR VGND net207 sg13g2_dlygate4sd3_1
XFILLER_29_66 VPWR VGND sg13g2_fill_1
Xhold99 falutop.i2c_inst.result\[12\] VPWR VGND net273 sg13g2_dlygate4sd3_1
Xhold88 _0093_ VPWR VGND net262 sg13g2_dlygate4sd3_1
Xhold66 falutop.div_inst.b\[7\] VPWR VGND net240 sg13g2_dlygate4sd3_1
XFILLER_29_643 VPWR VGND sg13g2_decap_8
XFILLER_29_654 VPWR VGND sg13g2_fill_1
XFILLER_29_665 VPWR VGND sg13g2_fill_1
Xhold77 _0094_ VPWR VGND net251 sg13g2_dlygate4sd3_1
XFILLER_17_849 VPWR VGND sg13g2_decap_8
XFILLER_43_156 VPWR VGND sg13g2_decap_8
XFILLER_25_882 VPWR VGND sg13g2_decap_8
XFILLER_40_863 VPWR VGND sg13g2_decap_8
XFILLER_12_554 VPWR VGND sg13g2_decap_8
XFILLER_8_536 VPWR VGND sg13g2_decap_8
XFILLER_4_720 VPWR VGND sg13g2_decap_8
XFILLER_3_241 VPWR VGND sg13g2_fill_2
XFILLER_4_797 VPWR VGND sg13g2_decap_8
XFILLER_0_981 VPWR VGND sg13g2_decap_8
XFILLER_48_941 VPWR VGND sg13g2_decap_8
X_2050_ _0525_ _0460_ _0523_ VPWR VGND sg13g2_xnor2_1
XFILLER_19_197 VPWR VGND sg13g2_decap_8
XFILLER_34_123 VPWR VGND sg13g2_decap_8
XFILLER_35_635 VPWR VGND sg13g2_decap_8
XFILLER_35_657 VPWR VGND sg13g2_fill_1
XFILLER_22_307 VPWR VGND sg13g2_fill_1
XFILLER_15_381 VPWR VGND sg13g2_decap_8
XFILLER_22_318 VPWR VGND sg13g2_decap_8
X_2952_ net42 VGND VPWR _0109_ falutop.alu_data_in\[12\] clknet_4_9_0_clk sg13g2_dfrbpq_1
XFILLER_31_863 VPWR VGND sg13g2_decap_8
X_1903_ _0381_ net332 net367 VPWR VGND sg13g2_nand2_1
X_2883_ net47 VGND VPWR _0040_ falutop.data_in\[12\] net392 sg13g2_dfrbpq_2
XFILLER_31_885 VPWR VGND sg13g2_decap_8
XFILLER_30_395 VPWR VGND sg13g2_decap_8
X_1834_ net291 VPWR _0314_ VGND _0301_ _0313_ sg13g2_o21ai_1
X_1765_ _0246_ net334 net358 VPWR VGND sg13g2_nand2_2
X_1696_ _0178_ _0956_ _0177_ VPWR VGND sg13g2_xnor2_1
X_2317_ VPWR _0736_ net190 VGND sg13g2_inv_1
X_2248_ net408 VPWR _0687_ VGND falutop.i2c_inst.data_in\[19\] _0686_ sg13g2_o21ai_1
XFILLER_39_952 VPWR VGND sg13g2_decap_8
Xheichips25_template_24 VPWR VGND uo_out[4] sg13g2_tielo
Xheichips25_template_13 VPWR VGND uio_out[0] sg13g2_tielo
X_2179_ falutop.data_in\[8\] net294 _0640_ VPWR VGND sg13g2_nor2_1
XFILLER_25_101 VPWR VGND sg13g2_decap_8
XFILLER_41_616 VPWR VGND sg13g2_decap_8
XFILLER_41_627 VPWR VGND sg13g2_decap_8
XFILLER_40_126 VPWR VGND sg13g2_decap_8
XFILLER_15_79 VPWR VGND sg13g2_decap_4
XFILLER_34_690 VPWR VGND sg13g2_decap_8
XFILLER_21_384 VPWR VGND sg13g2_decap_8
XFILLER_5_506 VPWR VGND sg13g2_decap_8
XFILLER_31_78 VPWR VGND sg13g2_decap_8
XFILLER_0_200 VPWR VGND sg13g2_decap_8
XFILLER_0_255 VPWR VGND sg13g2_decap_8
XFILLER_1_756 VPWR VGND sg13g2_decap_8
XFILLER_49_727 VPWR VGND sg13g2_decap_8
XFILLER_0_277 VPWR VGND sg13g2_decap_8
XFILLER_17_613 VPWR VGND sg13g2_fill_1
XFILLER_45_933 VPWR VGND sg13g2_decap_8
XFILLER_16_112 VPWR VGND sg13g2_decap_4
XFILLER_17_624 VPWR VGND sg13g2_decap_8
XFILLER_29_495 VPWR VGND sg13g2_fill_1
XFILLER_16_167 VPWR VGND sg13g2_decap_4
XFILLER_13_863 VPWR VGND sg13g2_decap_8
XFILLER_8_311 VPWR VGND sg13g2_decap_8
XFILLER_9_812 VPWR VGND sg13g2_decap_8
XFILLER_9_889 VPWR VGND sg13g2_decap_8
X_1550_ _1214_ _1234_ _1235_ VPWR VGND sg13g2_nor2_1
XFILLER_4_594 VPWR VGND sg13g2_decap_8
XFILLER_39_215 VPWR VGND sg13g2_decap_8
X_2102_ _0575_ _0572_ _1141_ _0576_ VPWR VGND sg13g2_a21o_1
XFILLER_47_281 VPWR VGND sg13g2_decap_8
XFILLER_36_944 VPWR VGND sg13g2_decap_8
X_2033_ _1329_ _0507_ _0508_ VPWR VGND sg13g2_nor2_1
XFILLER_35_487 VPWR VGND sg13g2_decap_8
XFILLER_23_649 VPWR VGND sg13g2_decap_8
XFILLER_22_159 VPWR VGND sg13g2_decap_8
X_2935_ net108 VGND VPWR net272 falutop.i2c_inst.result\[13\] clknet_4_13_0_clk sg13g2_dfrbpq_1
XFILLER_31_682 VPWR VGND sg13g2_fill_1
X_2866_ net68 VGND VPWR _0023_ falutop.i2c_inst.counter\[1\] net395 sg13g2_dfrbpq_2
XFILLER_11_1002 VPWR VGND sg13g2_decap_8
X_1817_ net357 _0296_ _0297_ VPWR VGND sg13g2_and2_1
X_2797_ VGND VPWR falutop.div_inst.val\[1\] _1135_ _1136_ net315 sg13g2_a21oi_1
X_1748_ net329 _0228_ net343 _0229_ VPWR VGND sg13g2_nand3_1
X_1679_ _0159_ _0160_ _0150_ _0161_ VPWR VGND sg13g2_nand3_1
XFILLER_46_708 VPWR VGND sg13g2_decap_8
XFILLER_39_793 VPWR VGND sg13g2_decap_4
XFILLER_38_270 VPWR VGND sg13g2_decap_8
XFILLER_42_914 VPWR VGND sg13g2_decap_8
XFILLER_14_605 VPWR VGND sg13g2_decap_8
XFILLER_26_45 VPWR VGND sg13g2_decap_8
XFILLER_26_56 VPWR VGND sg13g2_fill_1
XFILLER_26_432 VPWR VGND sg13g2_decap_4
XFILLER_26_454 VPWR VGND sg13g2_fill_1
XFILLER_27_966 VPWR VGND sg13g2_decap_8
XFILLER_14_627 VPWR VGND sg13g2_decap_8
XFILLER_22_693 VPWR VGND sg13g2_decap_8
XFILLER_6_804 VPWR VGND sg13g2_decap_8
XFILLER_10_855 VPWR VGND sg13g2_decap_8
XFILLER_1_553 VPWR VGND sg13g2_decap_8
XFILLER_18_933 VPWR VGND sg13g2_decap_8
XFILLER_17_454 VPWR VGND sg13g2_decap_4
XFILLER_33_925 VPWR VGND sg13g2_decap_8
XFILLER_44_295 VPWR VGND sg13g2_fill_2
XFILLER_32_446 VPWR VGND sg13g2_fill_1
XFILLER_32_457 VPWR VGND sg13g2_decap_8
XFILLER_32_468 VPWR VGND sg13g2_fill_1
XFILLER_34_1013 VPWR VGND sg13g2_decap_8
XFILLER_8_130 VPWR VGND sg13g2_decap_8
XFILLER_13_682 VPWR VGND sg13g2_decap_8
X_2720_ _1060_ net323 _1059_ VPWR VGND sg13g2_nand2_1
X_2651_ _0949_ VPWR _0991_ VGND _0983_ _0984_ sg13g2_o21ai_1
XFILLER_8_163 VPWR VGND sg13g2_decap_8
XFILLER_9_686 VPWR VGND sg13g2_decap_8
X_1602_ net308 _1284_ _1286_ VPWR VGND _1285_ sg13g2_nand3b_1
X_2582_ VGND VPWR _0738_ net309 _0065_ _0935_ sg13g2_a21oi_1
XFILLER_5_870 VPWR VGND sg13g2_decap_8
X_1533_ _1217_ _0966_ _1218_ VPWR VGND sg13g2_xor2_1
XFILLER_41_1028 VPWR VGND sg13g2_fill_1
XFILLER_41_1017 VPWR VGND sg13g2_decap_8
X_2016_ _0492_ net381 falutop.div_inst.rem\[2\] VPWR VGND sg13g2_nand2_1
XFILLER_36_741 VPWR VGND sg13g2_fill_2
XFILLER_24_947 VPWR VGND sg13g2_decap_8
XFILLER_35_273 VPWR VGND sg13g2_decap_8
XFILLER_35_284 VPWR VGND sg13g2_fill_1
XFILLER_23_479 VPWR VGND sg13g2_decap_4
XFILLER_10_118 VPWR VGND sg13g2_decap_4
X_2918_ net142 VGND VPWR _0075_ falutop.div_inst.rem\[4\] clknet_4_8_0_clk sg13g2_dfrbpq_1
X_2849_ net96 VGND VPWR net181 falutop.div_inst.acc_next\[0\] clknet_4_4_0_clk sg13g2_dfrbpq_1
XFILLER_2_339 VPWR VGND sg13g2_decap_8
Xhold130 falutop.alu_data_in\[12\] VPWR VGND net437 sg13g2_dlygate4sd3_1
XFILLER_46_538 VPWR VGND sg13g2_decap_8
XFILLER_2_1022 VPWR VGND sg13g2_decap_8
XFILLER_37_99 VPWR VGND sg13g2_decap_8
XFILLER_37_77 VPWR VGND sg13g2_decap_8
XFILLER_42_722 VPWR VGND sg13g2_fill_2
XFILLER_26_273 VPWR VGND sg13g2_decap_8
XFILLER_27_774 VPWR VGND sg13g2_decap_8
XFILLER_27_785 VPWR VGND sg13g2_fill_2
XFILLER_41_210 VPWR VGND sg13g2_decap_4
XFILLER_15_947 VPWR VGND sg13g2_decap_8
XFILLER_42_788 VPWR VGND sg13g2_decap_8
XFILLER_6_601 VPWR VGND sg13g2_decap_8
XFILLER_10_652 VPWR VGND sg13g2_decap_8
XFILLER_5_100 VPWR VGND sg13g2_decap_8
XFILLER_6_678 VPWR VGND sg13g2_decap_8
XFILLER_5_199 VPWR VGND sg13g2_decap_8
XFILLER_2_840 VPWR VGND sg13g2_decap_8
XFILLER_49_332 VPWR VGND sg13g2_decap_8
XFILLER_49_365 VPWR VGND sg13g2_decap_8
XFILLER_37_527 VPWR VGND sg13g2_decap_8
XFILLER_33_700 VPWR VGND sg13g2_fill_2
XFILLER_32_210 VPWR VGND sg13g2_decap_8
XFILLER_32_232 VPWR VGND sg13g2_decap_8
XFILLER_21_939 VPWR VGND sg13g2_decap_8
XFILLER_33_788 VPWR VGND sg13g2_decap_8
XFILLER_20_449 VPWR VGND sg13g2_decap_8
XFILLER_9_483 VPWR VGND sg13g2_decap_8
X_2703_ net380 net379 _1042_ _1043_ VPWR VGND sg13g2_nor3_2
X_2634_ _0974_ net350 net373 VPWR VGND sg13g2_nand2_2
X_2565_ _0930_ _0774_ net243 falutop.div_inst.b\[0\] net386 VPWR VGND sg13g2_a22oi_1
X_1516_ _1201_ net369 net349 net373 net347 VPWR VGND sg13g2_a22oi_1
X_2496_ _0869_ _0889_ _0890_ VPWR VGND sg13g2_nor2_1
XFILLER_4_70 VPWR VGND sg13g2_fill_1
XFILLER_28_505 VPWR VGND sg13g2_decap_8
XFILLER_28_516 VPWR VGND sg13g2_fill_2
XFILLER_28_527 VPWR VGND sg13g2_decap_8
XFILLER_43_508 VPWR VGND sg13g2_decap_4
X_2862__75 VPWR VGND net75 sg13g2_tiehi
XFILLER_23_210 VPWR VGND sg13g2_decap_8
XFILLER_11_405 VPWR VGND sg13g2_decap_8
XFILLER_24_766 VPWR VGND sg13g2_decap_8
XFILLER_7_409 VPWR VGND sg13g2_decap_4
XFILLER_20_950 VPWR VGND sg13g2_decap_8
XFILLER_23_57 VPWR VGND sg13g2_decap_8
XFILLER_2_103 VPWR VGND sg13g2_fill_1
XFILLER_3_648 VPWR VGND sg13g2_decap_8
XFILLER_2_125 VPWR VGND sg13g2_decap_8
XFILLER_48_21 VPWR VGND sg13g2_decap_8
XFILLER_48_54 VPWR VGND sg13g2_decap_8
XFILLER_47_847 VPWR VGND sg13g2_decap_8
XFILLER_19_538 VPWR VGND sg13g2_decap_8
XFILLER_0_28 VPWR VGND sg13g2_decap_8
XFILLER_14_221 VPWR VGND sg13g2_fill_2
XFILLER_30_758 VPWR VGND sg13g2_decap_8
XFILLER_30_769 VPWR VGND sg13g2_fill_1
XFILLER_7_954 VPWR VGND sg13g2_decap_8
XFILLER_6_475 VPWR VGND sg13g2_decap_8
X_2350_ net225 net228 net240 net185 _0769_ VPWR VGND sg13g2_nor4_1
X_2281_ _0689_ _0707_ _0710_ VPWR VGND sg13g2_nor2_1
XFILLER_29_4 VPWR VGND sg13g2_decap_8
XFILLER_49_184 VPWR VGND sg13g2_decap_8
XFILLER_38_869 VPWR VGND sg13g2_decap_8
XFILLER_37_379 VPWR VGND sg13g2_fill_2
XFILLER_18_571 VPWR VGND sg13g2_decap_8
XFILLER_33_563 VPWR VGND sg13g2_decap_4
XFILLER_33_574 VPWR VGND sg13g2_fill_1
X_1996_ _0472_ _0426_ _0469_ VPWR VGND sg13g2_xnor2_1
XFILLER_20_246 VPWR VGND sg13g2_fill_1
XFILLER_21_769 VPWR VGND sg13g2_decap_4
XFILLER_9_291 VPWR VGND sg13g2_decap_8
XFILLER_47_1001 VPWR VGND sg13g2_decap_8
X_2617_ _0957_ _0753_ net365 VPWR VGND sg13g2_nand2_1
X_2548_ _0765_ _0766_ _0921_ VPWR VGND sg13g2_nor2_1
X_2479_ VPWR VGND _0868_ _0866_ _0876_ _0743_ _0021_ _0875_ sg13g2_a221oi_1
XFILLER_29_825 VPWR VGND sg13g2_decap_4
XFILLER_28_335 VPWR VGND sg13g2_decap_8
XFILLER_37_880 VPWR VGND sg13g2_decap_8
XFILLER_28_379 VPWR VGND sg13g2_decap_8
XFILLER_8_718 VPWR VGND sg13g2_decap_8
XFILLER_12_758 VPWR VGND sg13g2_decap_8
XFILLER_7_217 VPWR VGND sg13g2_decap_4
Xclkload0 VPWR clkload0/Y clknet_4_1_0_clk VGND sg13g2_inv_1
XFILLER_4_902 VPWR VGND sg13g2_decap_8
XFILLER_3_445 VPWR VGND sg13g2_decap_8
XFILLER_4_979 VPWR VGND sg13g2_decap_8
XFILLER_19_302 VPWR VGND sg13g2_decap_8
Xfanout281 _0991_ net281 VPWR VGND sg13g2_buf_1
Xfanout292 _1070_ net292 VPWR VGND sg13g2_buf_8
XFILLER_47_633 VPWR VGND sg13g2_fill_1
XFILLER_35_806 VPWR VGND sg13g2_fill_2
XFILLER_46_176 VPWR VGND sg13g2_decap_8
XFILLER_46_154 VPWR VGND sg13g2_fill_2
XFILLER_34_338 VPWR VGND sg13g2_decap_8
XFILLER_43_850 VPWR VGND sg13g2_decap_8
XFILLER_42_393 VPWR VGND sg13g2_fill_1
X_1850_ _0327_ _0328_ _0329_ VPWR VGND sg13g2_nor2b_1
X_1781_ net329 net374 _0261_ VPWR VGND sg13g2_and2_1
XFILLER_7_751 VPWR VGND sg13g2_decap_8
X_2402_ _0807_ VPWR _0813_ VGND _0811_ _0812_ sg13g2_o21ai_1
X_2333_ net336 _0752_ VPWR VGND sg13g2_inv_4
X_2264_ _0877_ _0697_ _0698_ VPWR VGND sg13g2_nor2_1
XFILLER_38_633 VPWR VGND sg13g2_decap_4
X_2195_ net263 falutop.data_in\[0\] net301 _0113_ VPWR VGND sg13g2_mux2_1
XFILLER_37_154 VPWR VGND sg13g2_decap_8
XFILLER_1_60 VPWR VGND sg13g2_fill_2
XFILLER_19_891 VPWR VGND sg13g2_decap_8
XFILLER_41_809 VPWR VGND sg13g2_fill_1
XFILLER_33_360 VPWR VGND sg13g2_decap_8
XFILLER_34_894 VPWR VGND sg13g2_decap_8
XFILLER_21_577 VPWR VGND sg13g2_decap_8
XFILLER_21_588 VPWR VGND sg13g2_decap_8
X_1979_ net407 VPWR _0456_ VGND net266 net306 sg13g2_o21ai_1
XFILLER_20_25 VPWR VGND sg13g2_decap_8
XFILLER_1_938 VPWR VGND sg13g2_decap_8
XFILLER_49_909 VPWR VGND sg13g2_decap_8
Xhold12 falutop.div_inst.acc\[7\] VPWR VGND net186 sg13g2_dlygate4sd3_1
Xhold23 _0005_ VPWR VGND net197 sg13g2_dlygate4sd3_1
Xhold34 _0013_ VPWR VGND net208 sg13g2_dlygate4sd3_1
Xhold56 falutop.div_inst.val\[1\] VPWR VGND net230 sg13g2_dlygate4sd3_1
Xhold45 falutop.div_inst.val\[5\] VPWR VGND net219 sg13g2_dlygate4sd3_1
XFILLER_29_600 VPWR VGND sg13g2_decap_8
Xhold78 falutop.alu_inst.op\[1\] VPWR VGND net252 sg13g2_dlygate4sd3_1
Xhold89 falutop.div_inst.b\[0\] VPWR VGND net263 sg13g2_dlygate4sd3_1
Xhold67 falutop.div_inst.a\[7\] VPWR VGND net241 sg13g2_dlygate4sd3_1
XFILLER_17_828 VPWR VGND sg13g2_decap_8
XFILLER_45_44 VPWR VGND sg13g2_decap_8
XFILLER_45_33 VPWR VGND sg13g2_fill_1
XFILLER_44_658 VPWR VGND sg13g2_fill_1
XFILLER_44_625 VPWR VGND sg13g2_fill_1
XFILLER_43_113 VPWR VGND sg13g2_decap_8
XFILLER_45_99 VPWR VGND sg13g2_decap_8
XFILLER_45_66 VPWR VGND sg13g2_fill_1
XFILLER_43_135 VPWR VGND sg13g2_decap_8
XFILLER_31_308 VPWR VGND sg13g2_decap_8
XFILLER_24_371 VPWR VGND sg13g2_decap_8
XFILLER_40_842 VPWR VGND sg13g2_fill_1
XFILLER_12_533 VPWR VGND sg13g2_decap_8
XFILLER_8_515 VPWR VGND sg13g2_decap_8
XFILLER_3_220 VPWR VGND sg13g2_decap_8
XFILLER_4_776 VPWR VGND sg13g2_decap_8
XFILLER_39_408 VPWR VGND sg13g2_fill_1
XFILLER_48_920 VPWR VGND sg13g2_decap_8
XFILLER_0_960 VPWR VGND sg13g2_decap_8
XFILLER_47_441 VPWR VGND sg13g2_decap_8
XFILLER_48_997 VPWR VGND sg13g2_decap_8
XFILLER_19_187 VPWR VGND sg13g2_fill_1
XFILLER_35_669 VPWR VGND sg13g2_decap_8
XFILLER_15_360 VPWR VGND sg13g2_decap_8
XFILLER_16_883 VPWR VGND sg13g2_decap_8
X_2951_ net61 VGND VPWR _0108_ falutop.alu_data_in\[11\] clknet_4_11_0_clk sg13g2_dfrbpq_1
XFILLER_30_330 VPWR VGND sg13g2_decap_8
XFILLER_31_842 VPWR VGND sg13g2_decap_8
X_1902_ VGND VPWR _0272_ _0343_ _0380_ _0342_ sg13g2_a21oi_1
X_2882_ net48 VGND VPWR _0039_ falutop.data_in\[11\] net392 sg13g2_dfrbpq_2
X_1833_ _0305_ _0309_ _0294_ _0313_ VPWR VGND _0312_ sg13g2_nand4_1
X_1764_ _0245_ net324 _0761_ VPWR VGND sg13g2_nand2_1
X_1695_ _0959_ VPWR _0177_ VGND _0960_ _1289_ sg13g2_o21ai_1
XFILLER_44_1026 VPWR VGND sg13g2_fill_2
X_2316_ VPWR _0735_ net182 VGND sg13g2_inv_1
X_2247_ _0684_ _0685_ _0686_ VPWR VGND sg13g2_nor2_1
XFILLER_39_931 VPWR VGND sg13g2_decap_8
Xheichips25_template_25 VPWR VGND uo_out[5] sg13g2_tielo
Xheichips25_template_14 VPWR VGND uio_out[1] sg13g2_tielo
X_2178_ VGND VPWR _0760_ net296 _0104_ _0639_ sg13g2_a21oi_1
XFILLER_40_105 VPWR VGND sg13g2_decap_8
XFILLER_40_149 VPWR VGND sg13g2_decap_8
XFILLER_21_352 VPWR VGND sg13g2_decap_8
XFILLER_22_886 VPWR VGND sg13g2_decap_8
XFILLER_31_57 VPWR VGND sg13g2_decap_8
XFILLER_1_735 VPWR VGND sg13g2_decap_8
XFILLER_49_706 VPWR VGND sg13g2_decap_8
XFILLER_0_234 VPWR VGND sg13g2_decap_8
XFILLER_48_205 VPWR VGND sg13g2_fill_2
XFILLER_48_249 VPWR VGND sg13g2_decap_8
XFILLER_45_912 VPWR VGND sg13g2_decap_8
XFILLER_29_452 VPWR VGND sg13g2_fill_2
XFILLER_45_989 VPWR VGND sg13g2_decap_8
XFILLER_44_444 VPWR VGND sg13g2_fill_1
XFILLER_44_433 VPWR VGND sg13g2_decap_8
XFILLER_17_669 VPWR VGND sg13g2_decap_8
XFILLER_44_488 VPWR VGND sg13g2_decap_8
XFILLER_12_330 VPWR VGND sg13g2_decap_4
XFILLER_13_842 VPWR VGND sg13g2_decap_8
XFILLER_31_127 VPWR VGND sg13g2_decap_8
XFILLER_40_683 VPWR VGND sg13g2_decap_8
XFILLER_9_868 VPWR VGND sg13g2_decap_8
XFILLER_12_385 VPWR VGND sg13g2_decap_8
XFILLER_21_90 VPWR VGND sg13g2_decap_8
XFILLER_4_573 VPWR VGND sg13g2_decap_8
XFILLER_39_238 VPWR VGND sg13g2_decap_8
X_2101_ _0360_ _0574_ _0575_ VPWR VGND sg13g2_nor2_1
XFILLER_11_4 VPWR VGND sg13g2_decap_8
X_2032_ net329 VPWR _0507_ VGND net364 net360 sg13g2_o21ai_1
XFILLER_48_794 VPWR VGND sg13g2_decap_8
XFILLER_36_923 VPWR VGND sg13g2_decap_8
XFILLER_35_422 VPWR VGND sg13g2_fill_2
XFILLER_23_606 VPWR VGND sg13g2_decap_8
XFILLER_35_455 VPWR VGND sg13g2_decap_4
XFILLER_22_105 VPWR VGND sg13g2_decap_8
XFILLER_23_628 VPWR VGND sg13g2_decap_8
XFILLER_22_149 VPWR VGND sg13g2_fill_1
X_2934_ net110 VGND VPWR _0091_ falutop.i2c_inst.result\[12\] clknet_4_14_0_clk sg13g2_dfrbpq_1
XFILLER_31_661 VPWR VGND sg13g2_decap_8
X_2865_ net70 VGND VPWR _0022_ falutop.i2c_inst.counter\[0\] net396 sg13g2_dfrbpq_2
XFILLER_31_694 VPWR VGND sg13g2_decap_8
X_1816_ _0229_ VPWR _0296_ VGND _0761_ _0227_ sg13g2_o21ai_1
X_2796_ _1135_ falutop.div_inst.val\[0\] net318 VPWR VGND sg13g2_nand2_1
X_1747_ _0228_ net359 _0227_ VPWR VGND sg13g2_xnor2_1
X_1678_ _1307_ VPWR _0160_ VGND _0156_ _0158_ sg13g2_o21ai_1
XFILLER_39_772 VPWR VGND sg13g2_decap_8
XFILLER_26_24 VPWR VGND sg13g2_decap_8
XFILLER_27_945 VPWR VGND sg13g2_decap_8
XFILLER_26_477 VPWR VGND sg13g2_decap_4
XFILLER_41_469 VPWR VGND sg13g2_decap_8
XFILLER_10_834 VPWR VGND sg13g2_decap_8
XFILLER_22_672 VPWR VGND sg13g2_fill_2
XFILLER_5_304 VPWR VGND sg13g2_fill_2
XFILLER_1_532 VPWR VGND sg13g2_decap_8
XFILLER_3_39 VPWR VGND sg13g2_decap_4
XFILLER_49_569 VPWR VGND sg13g2_fill_2
XFILLER_18_912 VPWR VGND sg13g2_decap_8
XFILLER_33_904 VPWR VGND sg13g2_decap_8
XFILLER_45_786 VPWR VGND sg13g2_decap_8
XFILLER_44_274 VPWR VGND sg13g2_fill_2
XFILLER_44_263 VPWR VGND sg13g2_decap_8
XFILLER_18_989 VPWR VGND sg13g2_decap_8
XFILLER_13_661 VPWR VGND sg13g2_decap_8
XFILLER_16_90 VPWR VGND sg13g2_decap_8
XFILLER_9_665 VPWR VGND sg13g2_decap_8
X_2650_ VPWR _0990_ _0989_ VGND sg13g2_inv_1
X_1601_ VGND VPWR _1161_ _1255_ _1285_ _1283_ sg13g2_a21oi_1
X_2581_ net404 VPWR _0935_ VGND net224 net309 sg13g2_o21ai_1
X_1532_ _1173_ _0971_ _0968_ _1217_ VPWR VGND sg13g2_a21o_1
XFILLER_48_580 VPWR VGND sg13g2_decap_4
XFILLER_36_720 VPWR VGND sg13g2_decap_8
X_2015_ _0490_ VPWR _0491_ VGND net292 _0487_ sg13g2_o21ai_1
XFILLER_36_731 VPWR VGND sg13g2_fill_1
XFILLER_24_926 VPWR VGND sg13g2_decap_8
XFILLER_35_252 VPWR VGND sg13g2_decap_8
X_2917_ net144 VGND VPWR _0074_ falutop.div_inst.rem\[3\] clknet_4_3_0_clk sg13g2_dfrbpq_2
XFILLER_32_981 VPWR VGND sg13g2_decap_8
X_2848_ net97 VGND VPWR net197 falutop.div_inst.quo\[6\] clknet_4_4_0_clk sg13g2_dfrbpq_1
X_2779_ _0975_ _1046_ _1118_ VPWR VGND sg13g2_nor2_1
Xhold120 falutop.alu_inst.op\[2\] VPWR VGND net427 sg13g2_dlygate4sd3_1
XFILLER_2_329 VPWR VGND sg13g2_fill_1
Xhold131 falutop.alu_data_in\[1\] VPWR VGND net438 sg13g2_dlygate4sd3_1
XFILLER_2_1001 VPWR VGND sg13g2_decap_8
XFILLER_27_753 VPWR VGND sg13g2_decap_8
XFILLER_15_926 VPWR VGND sg13g2_decap_8
XFILLER_26_252 VPWR VGND sg13g2_decap_8
XFILLER_42_756 VPWR VGND sg13g2_fill_1
XFILLER_42_745 VPWR VGND sg13g2_decap_8
XFILLER_42_778 VPWR VGND sg13g2_fill_2
XFILLER_42_767 VPWR VGND sg13g2_fill_2
XFILLER_41_255 VPWR VGND sg13g2_fill_1
XFILLER_41_244 VPWR VGND sg13g2_decap_8
XFILLER_23_981 VPWR VGND sg13g2_decap_8
XFILLER_10_631 VPWR VGND sg13g2_decap_8
XFILLER_6_657 VPWR VGND sg13g2_decap_8
XFILLER_5_178 VPWR VGND sg13g2_decap_8
X_2958__163 VPWR VGND net163 sg13g2_tiehi
XFILLER_38_9 VPWR VGND sg13g2_fill_1
XFILLER_49_311 VPWR VGND sg13g2_decap_8
XFILLER_2_896 VPWR VGND sg13g2_decap_8
X_2856__84 VPWR VGND net84 sg13g2_tiehi
XFILLER_17_252 VPWR VGND sg13g2_decap_8
XFILLER_18_764 VPWR VGND sg13g2_fill_2
XFILLER_17_296 VPWR VGND sg13g2_decap_8
XFILLER_33_723 VPWR VGND sg13g2_decap_8
XFILLER_33_745 VPWR VGND sg13g2_decap_8
XFILLER_21_918 VPWR VGND sg13g2_decap_8
XFILLER_14_992 VPWR VGND sg13g2_decap_8
X_2702_ _1042_ falutop.alu_inst.op\[0\] _0758_ VPWR VGND sg13g2_nand2_1
XFILLER_9_440 VPWR VGND sg13g2_fill_2
XFILLER_13_480 VPWR VGND sg13g2_decap_8
X_2633_ net350 net372 _0973_ VPWR VGND sg13g2_and2_1
X_2564_ VGND VPWR _0740_ _0927_ _0053_ net388 sg13g2_a21oi_1
X_1515_ _0969_ _0974_ _1200_ VPWR VGND sg13g2_nor2_2
X_2495_ _0889_ falutop.i2c_inst.counter\[3\] _0873_ VPWR VGND sg13g2_xnor2_1
XFILLER_36_561 VPWR VGND sg13g2_decap_8
XFILLER_24_745 VPWR VGND sg13g2_decap_8
XFILLER_23_266 VPWR VGND sg13g2_decap_8
XFILLER_23_299 VPWR VGND sg13g2_fill_1
XFILLER_3_627 VPWR VGND sg13g2_decap_8
XFILLER_24_1024 VPWR VGND sg13g2_decap_4
XFILLER_47_826 VPWR VGND sg13g2_decap_8
XFILLER_27_561 VPWR VGND sg13g2_fill_2
XFILLER_42_553 VPWR VGND sg13g2_decap_8
XFILLER_15_767 VPWR VGND sg13g2_fill_1
XFILLER_30_704 VPWR VGND sg13g2_decap_4
XFILLER_9_49 VPWR VGND sg13g2_decap_8
XFILLER_14_277 VPWR VGND sg13g2_decap_8
XFILLER_14_288 VPWR VGND sg13g2_decap_8
XFILLER_7_933 VPWR VGND sg13g2_decap_8
XFILLER_11_995 VPWR VGND sg13g2_decap_8
XFILLER_6_454 VPWR VGND sg13g2_decap_8
XFILLER_43_7 VPWR VGND sg13g2_decap_8
X_2280_ VGND VPWR net389 _0708_ _0136_ _0709_ sg13g2_a21oi_1
XFILLER_2_693 VPWR VGND sg13g2_decap_8
XFILLER_49_163 VPWR VGND sg13g2_decap_8
XFILLER_38_848 VPWR VGND sg13g2_decap_8
XFILLER_25_509 VPWR VGND sg13g2_decap_8
XFILLER_18_594 VPWR VGND sg13g2_decap_8
XFILLER_33_531 VPWR VGND sg13g2_decap_8
XFILLER_21_704 VPWR VGND sg13g2_fill_1
XFILLER_21_726 VPWR VGND sg13g2_decap_8
XFILLER_33_597 VPWR VGND sg13g2_fill_1
X_1995_ _0425_ _0469_ _0471_ VPWR VGND sg13g2_nor2_1
XFILLER_9_270 VPWR VGND sg13g2_decap_8
XFILLER_20_258 VPWR VGND sg13g2_decap_8
X_2616_ VGND VPWR _0956_ _0954_ _0952_ sg13g2_or2_1
X_2547_ VPWR _0045_ net223 VGND sg13g2_inv_1
X_2478_ _0876_ _0862_ _0872_ VPWR VGND sg13g2_nand2_1
XFILLER_28_314 VPWR VGND sg13g2_fill_2
XFILLER_28_325 VPWR VGND sg13g2_decap_4
XFILLER_29_859 VPWR VGND sg13g2_decap_8
XFILLER_34_35 VPWR VGND sg13g2_decap_4
XFILLER_11_214 VPWR VGND sg13g2_decap_8
XFILLER_12_715 VPWR VGND sg13g2_fill_2
XFILLER_12_737 VPWR VGND sg13g2_decap_8
XFILLER_34_79 VPWR VGND sg13g2_decap_8
XFILLER_11_247 VPWR VGND sg13g2_fill_2
Xclkload1 VPWR clkload1/Y clknet_4_2_0_clk VGND sg13g2_inv_1
XFILLER_4_958 VPWR VGND sg13g2_decap_8
XFILLER_3_424 VPWR VGND sg13g2_decap_8
XFILLER_47_623 VPWR VGND sg13g2_decap_4
Xfanout282 _0824_ net282 VPWR VGND sg13g2_buf_8
XFILLER_46_133 VPWR VGND sg13g2_decap_8
Xfanout293 _1070_ net293 VPWR VGND sg13g2_buf_2
XFILLER_47_667 VPWR VGND sg13g2_decap_8
XFILLER_28_881 VPWR VGND sg13g2_decap_8
XFILLER_27_391 VPWR VGND sg13g2_decap_8
XFILLER_42_372 VPWR VGND sg13g2_decap_8
X_1780_ _0206_ VPWR _0260_ VGND _0204_ _0207_ sg13g2_o21ai_1
XFILLER_7_730 VPWR VGND sg13g2_decap_8
XFILLER_11_792 VPWR VGND sg13g2_decap_8
XFILLER_6_251 VPWR VGND sg13g2_decap_8
X_2401_ falutop.div_inst.acc\[2\] falutop.div_inst.b1\[2\] _0812_ VPWR VGND sg13g2_xor2_1
XFILLER_3_991 VPWR VGND sg13g2_decap_8
X_2332_ net348 _0751_ VPWR VGND sg13g2_inv_4
XFILLER_2_490 VPWR VGND sg13g2_decap_8
X_2263_ _0697_ falutop.i2c_inst.counter\[2\] _0861_ VPWR VGND sg13g2_nand2_2
XFILLER_38_601 VPWR VGND sg13g2_decap_8
X_2194_ VGND VPWR net323 net297 _0112_ _0647_ sg13g2_a21oi_1
XFILLER_19_870 VPWR VGND sg13g2_decap_8
XFILLER_26_807 VPWR VGND sg13g2_fill_2
XFILLER_18_380 VPWR VGND sg13g2_decap_8
XFILLER_40_309 VPWR VGND sg13g2_fill_1
XFILLER_21_512 VPWR VGND sg13g2_fill_1
X_1978_ VPWR VGND net316 net307 _0454_ net290 _0455_ _0452_ sg13g2_a221oi_1
XFILLER_20_59 VPWR VGND sg13g2_decap_8
XFILLER_1_917 VPWR VGND sg13g2_decap_8
Xhold13 _0014_ VPWR VGND net187 sg13g2_dlygate4sd3_1
XFILLER_0_449 VPWR VGND sg13g2_decap_8
Xhold46 falutop.div_inst.acc\[8\] VPWR VGND net220 sg13g2_dlygate4sd3_1
Xhold35 falutop.div_inst.acc\[1\] VPWR VGND net209 sg13g2_dlygate4sd3_1
Xhold24 falutop.div_inst.i\[2\] VPWR VGND net198 sg13g2_dlygate4sd3_1
XFILLER_29_46 VPWR VGND sg13g2_fill_2
Xhold79 falutop.div_inst.b1\[7\] VPWR VGND net253 sg13g2_dlygate4sd3_1
Xhold57 falutop.div_inst.i\[1\] VPWR VGND net231 sg13g2_dlygate4sd3_1
Xhold68 falutop.div_inst.b1\[2\] VPWR VGND net242 sg13g2_dlygate4sd3_1
XFILLER_21_1016 VPWR VGND sg13g2_decap_8
XFILLER_21_1027 VPWR VGND sg13g2_fill_2
XFILLER_44_604 VPWR VGND sg13g2_decap_8
XFILLER_28_199 VPWR VGND sg13g2_fill_2
XFILLER_25_851 VPWR VGND sg13g2_decap_8
XFILLER_12_512 VPWR VGND sg13g2_decap_8
XFILLER_24_350 VPWR VGND sg13g2_decap_8
XFILLER_40_898 VPWR VGND sg13g2_decap_8
XFILLER_12_589 VPWR VGND sg13g2_decap_4
XFILLER_6_39 VPWR VGND sg13g2_decap_8
XFILLER_4_755 VPWR VGND sg13g2_decap_8
XFILLER_47_420 VPWR VGND sg13g2_decap_8
XFILLER_48_976 VPWR VGND sg13g2_decap_8
XFILLER_19_90 VPWR VGND sg13g2_decap_8
XFILLER_47_497 VPWR VGND sg13g2_decap_4
XFILLER_19_166 VPWR VGND sg13g2_decap_8
XFILLER_16_862 VPWR VGND sg13g2_decap_8
XFILLER_43_681 VPWR VGND sg13g2_decap_8
X_2950_ net63 VGND VPWR _0107_ falutop.alu_data_in\[10\] clknet_4_12_0_clk sg13g2_dfrbpq_2
XFILLER_31_821 VPWR VGND sg13g2_decap_8
X_1901_ _0379_ _0263_ _0378_ VPWR VGND sg13g2_xnor2_1
X_2881_ net49 VGND VPWR _0038_ falutop.data_in\[10\] net394 sg13g2_dfrbpq_2
X_1832_ _0311_ VPWR _0312_ VGND _0989_ _0310_ sg13g2_o21ai_1
X_1763_ _0242_ _0951_ _0244_ VPWR VGND sg13g2_xor2_1
X_1694_ _1043_ _0175_ _0176_ VPWR VGND _0981_ sg13g2_nand3b_1
XFILLER_44_1005 VPWR VGND sg13g2_decap_8
XFILLER_39_910 VPWR VGND sg13g2_decap_8
X_2315_ VPWR _0734_ net192 VGND sg13g2_inv_1
XFILLER_38_420 VPWR VGND sg13g2_fill_2
X_2246_ _0685_ _0868_ _0902_ VPWR VGND sg13g2_nand2_2
Xheichips25_template_26 VPWR VGND uo_out[6] sg13g2_tielo
Xheichips25_template_15 VPWR VGND uio_out[2] sg13g2_tielo
XFILLER_39_987 VPWR VGND sg13g2_decap_8
X_2177_ falutop.data_in\[7\] net296 _0639_ VPWR VGND sg13g2_nor2_1
XFILLER_21_331 VPWR VGND sg13g2_decap_8
XFILLER_22_865 VPWR VGND sg13g2_decap_8
XFILLER_31_14 VPWR VGND sg13g2_decap_4
XFILLER_31_36 VPWR VGND sg13g2_decap_8
XFILLER_1_714 VPWR VGND sg13g2_decap_8
XFILLER_0_213 VPWR VGND sg13g2_decap_8
XFILLER_48_217 VPWR VGND sg13g2_decap_4
XFILLER_5_1010 VPWR VGND sg13g2_decap_8
XFILLER_44_412 VPWR VGND sg13g2_decap_8
XFILLER_29_475 VPWR VGND sg13g2_decap_8
XFILLER_45_968 VPWR VGND sg13g2_decap_8
XFILLER_31_106 VPWR VGND sg13g2_decap_8
XFILLER_13_821 VPWR VGND sg13g2_decap_8
XFILLER_24_180 VPWR VGND sg13g2_decap_8
XFILLER_40_662 VPWR VGND sg13g2_decap_8
XFILLER_9_847 VPWR VGND sg13g2_decap_8
XFILLER_12_364 VPWR VGND sg13g2_decap_8
XFILLER_13_898 VPWR VGND sg13g2_decap_8
XFILLER_4_552 VPWR VGND sg13g2_decap_8
X_2980__89 VPWR VGND net89 sg13g2_tiehi
X_2100_ VGND VPWR _0752_ net278 _0574_ _0573_ sg13g2_a21oi_1
XFILLER_48_773 VPWR VGND sg13g2_decap_8
X_2031_ _0474_ VPWR _0506_ VGND _0466_ _0475_ sg13g2_o21ai_1
XFILLER_36_902 VPWR VGND sg13g2_decap_8
XFILLER_47_250 VPWR VGND sg13g2_decap_8
X_2968__143 VPWR VGND net143 sg13g2_tiehi
XFILLER_36_979 VPWR VGND sg13g2_decap_8
X_2933_ net112 VGND VPWR net249 falutop.i2c_inst.result\[11\] clknet_4_13_0_clk sg13g2_dfrbpq_1
XFILLER_15_180 VPWR VGND sg13g2_decap_4
XFILLER_16_692 VPWR VGND sg13g2_decap_8
X_2864_ net72 VGND VPWR _0021_ falutop.i2c_inst.state\[1\] net393 sg13g2_dfrbpq_2
XFILLER_30_172 VPWR VGND sg13g2_decap_8
X_2795_ net381 net384 _1134_ VPWR VGND sg13g2_xor2_1
X_1815_ _0234_ _0236_ _0295_ VPWR VGND sg13g2_and2_1
X_1746_ VGND VPWR net350 _1329_ _0227_ _1333_ sg13g2_a21oi_1
X_1677_ _1307_ _0156_ _0158_ _0159_ VPWR VGND sg13g2_or3_1
X_2229_ _0672_ net175 net299 VPWR VGND sg13g2_nand2_1
XFILLER_26_412 VPWR VGND sg13g2_decap_8
XFILLER_27_924 VPWR VGND sg13g2_decap_8
XFILLER_41_404 VPWR VGND sg13g2_decap_8
XFILLER_42_949 VPWR VGND sg13g2_decap_8
XFILLER_41_437 VPWR VGND sg13g2_decap_8
XFILLER_35_990 VPWR VGND sg13g2_decap_8
XFILLER_22_651 VPWR VGND sg13g2_decap_8
XFILLER_10_813 VPWR VGND sg13g2_decap_8
XFILLER_21_150 VPWR VGND sg13g2_fill_1
XFILLER_6_839 VPWR VGND sg13g2_decap_8
XFILLER_5_338 VPWR VGND sg13g2_fill_2
XFILLER_1_511 VPWR VGND sg13g2_decap_8
XFILLER_3_18 VPWR VGND sg13g2_decap_8
XFILLER_27_1022 VPWR VGND sg13g2_decap_8
XFILLER_49_548 VPWR VGND sg13g2_decap_8
XFILLER_49_526 VPWR VGND sg13g2_decap_4
XFILLER_1_588 VPWR VGND sg13g2_decap_8
XFILLER_17_401 VPWR VGND sg13g2_decap_8
XFILLER_18_968 VPWR VGND sg13g2_decap_8
XFILLER_29_283 VPWR VGND sg13g2_decap_8
XFILLER_45_765 VPWR VGND sg13g2_decap_8
XFILLER_17_489 VPWR VGND sg13g2_fill_2
XFILLER_32_437 VPWR VGND sg13g2_decap_8
XFILLER_41_982 VPWR VGND sg13g2_decap_8
XFILLER_9_644 VPWR VGND sg13g2_decap_8
XFILLER_12_150 VPWR VGND sg13g2_decap_8
X_1600_ _1255_ _1283_ _1161_ _1284_ VPWR VGND sg13g2_nand3_1
XFILLER_32_90 VPWR VGND sg13g2_fill_2
X_2580_ VGND VPWR _0739_ net310 _0064_ _0934_ sg13g2_a21oi_1
X_1531_ _0979_ _1215_ _1216_ VPWR VGND sg13g2_and2_1
XFILLER_35_231 VPWR VGND sg13g2_decap_8
X_2014_ _0359_ _0489_ _0490_ VPWR VGND sg13g2_and2_1
XFILLER_24_905 VPWR VGND sg13g2_decap_8
XFILLER_36_765 VPWR VGND sg13g2_fill_2
XFILLER_23_437 VPWR VGND sg13g2_decap_8
XFILLER_32_960 VPWR VGND sg13g2_decap_8
X_2916_ net146 VGND VPWR _0073_ falutop.div_inst.rem\[2\] clknet_4_8_0_clk sg13g2_dfrbpq_1
XFILLER_12_27 VPWR VGND sg13g2_fill_2
X_2847_ net98 VGND VPWR _0004_ falutop.div_inst.quo\[5\] clknet_4_5_0_clk sg13g2_dfrbpq_1
XFILLER_12_38 VPWR VGND sg13g2_fill_2
XFILLER_3_809 VPWR VGND sg13g2_decap_8
Xhold110 _0943_ VPWR VGND net417 sg13g2_dlygate4sd3_1
X_2778_ _1117_ _0976_ _0999_ VPWR VGND sg13g2_xnor2_1
Xhold121 falutop.alu_data_in\[7\] VPWR VGND net428 sg13g2_dlygate4sd3_1
XFILLER_2_319 VPWR VGND sg13g2_decap_4
X_1729_ _0210_ net353 net359 VPWR VGND sg13g2_nand2_1
XFILLER_37_57 VPWR VGND sg13g2_fill_2
XFILLER_37_46 VPWR VGND sg13g2_decap_8
XFILLER_26_231 VPWR VGND sg13g2_decap_8
XFILLER_15_905 VPWR VGND sg13g2_decap_8
XFILLER_41_223 VPWR VGND sg13g2_fill_1
XFILLER_14_437 VPWR VGND sg13g2_decap_8
XFILLER_14_448 VPWR VGND sg13g2_fill_1
XFILLER_23_960 VPWR VGND sg13g2_decap_8
XFILLER_41_278 VPWR VGND sg13g2_decap_8
XFILLER_41_267 VPWR VGND sg13g2_decap_8
XFILLER_10_610 VPWR VGND sg13g2_decap_8
XFILLER_22_492 VPWR VGND sg13g2_decap_8
XFILLER_6_636 VPWR VGND sg13g2_decap_8
XFILLER_10_687 VPWR VGND sg13g2_decap_8
XFILLER_5_135 VPWR VGND sg13g2_decap_8
XFILLER_2_875 VPWR VGND sg13g2_decap_8
XFILLER_1_385 VPWR VGND sg13g2_decap_8
XFILLER_37_507 VPWR VGND sg13g2_decap_8
XFILLER_18_721 VPWR VGND sg13g2_decap_8
XFILLER_45_562 VPWR VGND sg13g2_fill_2
XFILLER_17_231 VPWR VGND sg13g2_decap_8
XFILLER_18_798 VPWR VGND sg13g2_decap_8
XFILLER_14_971 VPWR VGND sg13g2_decap_8
XFILLER_20_418 VPWR VGND sg13g2_decap_8
XFILLER_20_429 VPWR VGND sg13g2_fill_2
XFILLER_32_289 VPWR VGND sg13g2_decap_8
XFILLER_41_790 VPWR VGND sg13g2_decap_4
X_2701_ net380 falutop.alu_inst.op\[0\] net377 _1041_ VPWR VGND sg13g2_nor3_2
X_2632_ _0972_ _0749_ net372 VPWR VGND sg13g2_nand2_1
X_2563_ net388 _0928_ net232 _0052_ VPWR VGND sg13g2_nor3_1
X_1514_ _1198_ VPWR _1199_ VGND net345 net279 sg13g2_o21ai_1
X_2494_ falutop.i2c_inst.counter\[3\] _0873_ _0888_ VPWR VGND sg13g2_nor2b_1
XFILLER_36_540 VPWR VGND sg13g2_decap_8
XFILLER_24_724 VPWR VGND sg13g2_decap_8
XFILLER_36_595 VPWR VGND sg13g2_decap_8
XFILLER_12_919 VPWR VGND sg13g2_decap_8
XFILLER_23_245 VPWR VGND sg13g2_decap_8
XFILLER_11_429 VPWR VGND sg13g2_decap_8
XFILLER_17_1010 VPWR VGND sg13g2_decap_8
XFILLER_23_37 VPWR VGND sg13g2_decap_4
XFILLER_20_985 VPWR VGND sg13g2_decap_8
XFILLER_3_606 VPWR VGND sg13g2_decap_8
XFILLER_24_1003 VPWR VGND sg13g2_decap_8
XFILLER_47_805 VPWR VGND sg13g2_decap_8
XFILLER_19_518 VPWR VGND sg13g2_decap_4
XFILLER_46_359 VPWR VGND sg13g2_decap_8
XFILLER_15_735 VPWR VGND sg13g2_decap_8
XFILLER_15_746 VPWR VGND sg13g2_decap_8
XFILLER_42_532 VPWR VGND sg13g2_decap_8
XFILLER_14_234 VPWR VGND sg13g2_fill_2
XFILLER_14_256 VPWR VGND sg13g2_decap_8
XFILLER_15_779 VPWR VGND sg13g2_decap_8
XFILLER_42_576 VPWR VGND sg13g2_decap_8
XFILLER_9_28 VPWR VGND sg13g2_decap_8
XFILLER_7_912 VPWR VGND sg13g2_decap_8
XFILLER_11_974 VPWR VGND sg13g2_decap_8
XFILLER_31_1018 VPWR VGND sg13g2_decap_8
XFILLER_10_484 VPWR VGND sg13g2_fill_1
XFILLER_13_92 VPWR VGND sg13g2_decap_8
XFILLER_7_989 VPWR VGND sg13g2_decap_8
XFILLER_9_1008 VPWR VGND sg13g2_decap_8
XFILLER_2_672 VPWR VGND sg13g2_decap_8
XFILLER_49_142 VPWR VGND sg13g2_decap_8
XFILLER_18_540 VPWR VGND sg13g2_decap_8
XFILLER_18_551 VPWR VGND sg13g2_fill_1
X_1994_ _0470_ _0425_ _0469_ VPWR VGND sg13g2_nand2_1
XFILLER_20_226 VPWR VGND sg13g2_decap_8
XFILLER_20_237 VPWR VGND sg13g2_fill_1
X_2615_ _0952_ _0954_ _0955_ VPWR VGND sg13g2_nor2_2
X_2546_ _0920_ net282 _0767_ net289 net222 VPWR VGND sg13g2_a22oi_1
X_2477_ _0875_ _0874_ _0870_ _0871_ net2 VPWR VGND sg13g2_a22oi_1
XFILLER_24_532 VPWR VGND sg13g2_decap_8
XFILLER_34_14 VPWR VGND sg13g2_decap_8
XFILLER_36_392 VPWR VGND sg13g2_decap_4
XFILLER_34_58 VPWR VGND sg13g2_decap_8
XFILLER_11_226 VPWR VGND sg13g2_decap_8
Xclkload2 VPWR clkload2/Y clknet_4_3_0_clk VGND sg13g2_inv_1
XFILLER_4_937 VPWR VGND sg13g2_decap_8
XFILLER_47_602 VPWR VGND sg13g2_decap_8
Xfanout283 _0824_ net283 VPWR VGND sg13g2_buf_8
Xfanout294 net295 net294 VPWR VGND sg13g2_buf_8
XFILLER_19_337 VPWR VGND sg13g2_decap_8
XFILLER_47_679 VPWR VGND sg13g2_fill_2
XFILLER_46_156 VPWR VGND sg13g2_fill_1
XFILLER_28_860 VPWR VGND sg13g2_decap_8
XFILLER_15_532 VPWR VGND sg13g2_decap_8
XFILLER_43_885 VPWR VGND sg13g2_decap_8
XFILLER_15_576 VPWR VGND sg13g2_decap_4
XFILLER_30_524 VPWR VGND sg13g2_decap_8
XFILLER_30_568 VPWR VGND sg13g2_decap_8
XFILLER_11_771 VPWR VGND sg13g2_decap_8
XFILLER_7_786 VPWR VGND sg13g2_decap_8
XFILLER_6_230 VPWR VGND sg13g2_decap_8
X_2400_ VGND VPWR _0809_ _0810_ _0811_ _0808_ sg13g2_a21oi_1
X_2331_ net345 _0750_ VPWR VGND sg13g2_inv_4
XFILLER_3_970 VPWR VGND sg13g2_decap_8
X_2262_ VGND VPWR net390 _0695_ _0131_ _0696_ sg13g2_a21oi_1
X_2193_ net382 net297 _0647_ VPWR VGND sg13g2_nor2_1
XFILLER_38_657 VPWR VGND sg13g2_decap_8
XFILLER_37_189 VPWR VGND sg13g2_decap_8
XFILLER_34_863 VPWR VGND sg13g2_decap_8
XFILLER_34_874 VPWR VGND sg13g2_fill_1
XFILLER_21_535 VPWR VGND sg13g2_decap_8
XFILLER_14_1013 VPWR VGND sg13g2_decap_8
X_1977_ _0454_ falutop.div_inst.rem\[2\] _0453_ VPWR VGND sg13g2_xnor2_1
XFILLER_20_38 VPWR VGND sg13g2_decap_4
XFILLER_0_428 VPWR VGND sg13g2_decap_8
X_2529_ _0904_ _0902_ falutop.i2c_inst.result\[6\] _0872_ falutop.i2c_inst.result\[7\]
+ VPWR VGND sg13g2_a22oi_1
Xhold14 falutop.div_inst.quo\[1\] VPWR VGND net188 sg13g2_dlygate4sd3_1
XFILLER_29_25 VPWR VGND sg13g2_decap_8
Xhold25 _0053_ VPWR VGND net199 sg13g2_dlygate4sd3_1
Xhold47 _0854_ VPWR VGND net221 sg13g2_dlygate4sd3_1
Xhold36 _0008_ VPWR VGND net210 sg13g2_dlygate4sd3_1
Xhold58 _0929_ VPWR VGND net232 sg13g2_dlygate4sd3_1
Xhold69 falutop.div_inst.b1\[0\] VPWR VGND net243 sg13g2_dlygate4sd3_1
XFILLER_28_112 VPWR VGND sg13g2_fill_2
XFILLER_45_57 VPWR VGND sg13g2_decap_8
XFILLER_24_340 VPWR VGND sg13g2_decap_4
XFILLER_25_896 VPWR VGND sg13g2_decap_8
XFILLER_40_833 VPWR VGND sg13g2_decap_8
XFILLER_40_877 VPWR VGND sg13g2_decap_8
XFILLER_12_568 VPWR VGND sg13g2_decap_8
XFILLER_6_18 VPWR VGND sg13g2_decap_8
XFILLER_4_734 VPWR VGND sg13g2_decap_8
XFILLER_3_255 VPWR VGND sg13g2_decap_8
XFILLER_3_288 VPWR VGND sg13g2_decap_8
XFILLER_48_955 VPWR VGND sg13g2_decap_8
XFILLER_0_995 VPWR VGND sg13g2_decap_8
XFILLER_19_101 VPWR VGND sg13g2_fill_2
XFILLER_19_123 VPWR VGND sg13g2_decap_8
XFILLER_19_145 VPWR VGND sg13g2_decap_8
XFILLER_47_476 VPWR VGND sg13g2_decap_8
XFILLER_35_616 VPWR VGND sg13g2_fill_2
XFILLER_16_841 VPWR VGND sg13g2_decap_8
XFILLER_34_137 VPWR VGND sg13g2_fill_1
XFILLER_35_649 VPWR VGND sg13g2_decap_4
XFILLER_37_1013 VPWR VGND sg13g2_decap_8
XFILLER_15_395 VPWR VGND sg13g2_decap_8
X_2880_ net50 VGND VPWR _0037_ falutop.data_in\[9\] net394 sg13g2_dfrbpq_2
X_1900_ VGND VPWR _0952_ _0958_ _0378_ _0377_ sg13g2_a21oi_1
XFILLER_30_354 VPWR VGND sg13g2_decap_8
X_1831_ VGND VPWR _0989_ _0310_ _0311_ _1116_ sg13g2_a21oi_1
XFILLER_30_376 VPWR VGND sg13g2_decap_8
XFILLER_31_899 VPWR VGND sg13g2_decap_8
X_1762_ _0243_ _0951_ _0242_ VPWR VGND sg13g2_nand2_1
XFILLER_7_583 VPWR VGND sg13g2_decap_8
X_1693_ _0957_ _0980_ _0955_ _0175_ VPWR VGND sg13g2_nand3_1
XFILLER_44_1028 VPWR VGND sg13g2_fill_1
X_2314_ VPWR _0733_ net196 VGND sg13g2_inv_1
X_2245_ _0741_ falutop.i2c_inst.counter\[4\] _0684_ VPWR VGND falutop.i2c_inst.counter\[3\]
+ sg13g2_nand3b_1
Xheichips25_template_27 VPWR VGND uo_out[7] sg13g2_tielo
Xheichips25_template_16 VPWR VGND uio_out[3] sg13g2_tielo
X_2176_ VGND VPWR _0761_ net296 _0103_ _0638_ sg13g2_a21oi_1
XFILLER_39_966 VPWR VGND sg13g2_decap_8
XFILLER_38_454 VPWR VGND sg13g2_fill_2
XFILLER_38_443 VPWR VGND sg13g2_decap_8
XFILLER_26_605 VPWR VGND sg13g2_decap_8
XFILLER_25_115 VPWR VGND sg13g2_decap_8
XFILLER_26_616 VPWR VGND sg13g2_fill_1
XFILLER_26_638 VPWR VGND sg13g2_decap_8
XFILLER_22_811 VPWR VGND sg13g2_decap_8
XFILLER_21_310 VPWR VGND sg13g2_decap_8
XFILLER_33_170 VPWR VGND sg13g2_decap_8
XFILLER_21_398 VPWR VGND sg13g2_decap_4
XFILLER_0_269 VPWR VGND sg13g2_decap_4
XFILLER_29_454 VPWR VGND sg13g2_fill_1
XFILLER_45_947 VPWR VGND sg13g2_decap_8
XFILLER_16_104 VPWR VGND sg13g2_decap_4
XFILLER_17_638 VPWR VGND sg13g2_fill_2
XFILLER_13_800 VPWR VGND sg13g2_decap_8
XFILLER_9_826 VPWR VGND sg13g2_decap_8
XFILLER_13_877 VPWR VGND sg13g2_decap_8
XFILLER_4_531 VPWR VGND sg13g2_decap_8
XFILLER_39_229 VPWR VGND sg13g2_fill_1
XFILLER_0_792 VPWR VGND sg13g2_decap_8
XFILLER_48_752 VPWR VGND sg13g2_decap_8
X_2030_ _0505_ net327 _0503_ VPWR VGND sg13g2_xnor2_1
XFILLER_47_295 VPWR VGND sg13g2_decap_8
XFILLER_36_958 VPWR VGND sg13g2_decap_8
XFILLER_35_435 VPWR VGND sg13g2_decap_8
XFILLER_35_468 VPWR VGND sg13g2_fill_2
XFILLER_44_991 VPWR VGND sg13g2_decap_8
X_2932_ net114 VGND VPWR net267 falutop.i2c_inst.result\[10\] clknet_4_12_0_clk sg13g2_dfrbpq_1
XFILLER_31_641 VPWR VGND sg13g2_fill_2
X_2863_ net74 VGND VPWR _0020_ falutop.i2c_inst.state\[0\] net393 sg13g2_dfrbpq_2
XFILLER_30_151 VPWR VGND sg13g2_decap_8
X_2794_ VPWR VGND _0994_ _1132_ _1089_ _1014_ _1133_ _1088_ sg13g2_a221oi_1
X_1814_ _0293_ VPWR _0294_ VGND _0291_ _0292_ sg13g2_o21ai_1
XFILLER_7_50 VPWR VGND sg13g2_fill_1
XFILLER_11_1016 VPWR VGND sg13g2_decap_8
XFILLER_11_1027 VPWR VGND sg13g2_fill_2
X_1745_ VGND VPWR _1337_ _1338_ _0226_ _1341_ sg13g2_a21oi_1
X_1676_ _0158_ _0154_ _0155_ net366 net346 VPWR VGND sg13g2_a22oi_1
XFILLER_39_763 VPWR VGND sg13g2_decap_4
XFILLER_27_903 VPWR VGND sg13g2_decap_8
XFILLER_38_262 VPWR VGND sg13g2_decap_4
X_2228_ _0671_ VPWR _0122_ VGND net299 _0670_ sg13g2_o21ai_1
X_2912__154 VPWR VGND net154 sg13g2_tiehi
XFILLER_38_284 VPWR VGND sg13g2_decap_8
X_2159_ falutop.data_in\[0\] falutop.data_in\[1\] falutop.data_in\[2\] _0629_ VPWR
+ VGND sg13g2_nor3_1
XFILLER_42_928 VPWR VGND sg13g2_decap_8
XFILLER_41_416 VPWR VGND sg13g2_decap_8
XFILLER_22_630 VPWR VGND sg13g2_decap_8
XFILLER_6_818 VPWR VGND sg13g2_decap_8
XFILLER_10_869 VPWR VGND sg13g2_decap_8
XFILLER_5_317 VPWR VGND sg13g2_decap_8
XFILLER_27_1001 VPWR VGND sg13g2_decap_8
XFILLER_49_505 VPWR VGND sg13g2_decap_8
XFILLER_1_567 VPWR VGND sg13g2_decap_8
XFILLER_29_262 VPWR VGND sg13g2_decap_8
XFILLER_45_744 VPWR VGND sg13g2_decap_8
XFILLER_44_221 VPWR VGND sg13g2_fill_1
XFILLER_17_435 VPWR VGND sg13g2_fill_1
XFILLER_18_947 VPWR VGND sg13g2_decap_8
XFILLER_32_405 VPWR VGND sg13g2_fill_2
XFILLER_26_980 VPWR VGND sg13g2_decap_8
XFILLER_33_939 VPWR VGND sg13g2_decap_8
XFILLER_41_961 VPWR VGND sg13g2_decap_8
XFILLER_25_490 VPWR VGND sg13g2_fill_1
XFILLER_9_623 VPWR VGND sg13g2_decap_8
XFILLER_13_696 VPWR VGND sg13g2_decap_8
XFILLER_34_1027 VPWR VGND sg13g2_fill_2
XFILLER_8_144 VPWR VGND sg13g2_fill_1
XFILLER_12_173 VPWR VGND sg13g2_fill_2
XFILLER_8_177 VPWR VGND sg13g2_decap_8
XFILLER_5_884 VPWR VGND sg13g2_decap_8
X_1530_ _0967_ _0978_ _0966_ _1215_ VPWR VGND sg13g2_nand3_1
X_2013_ _0488_ VPWR _0489_ VGND net368 net281 sg13g2_o21ai_1
XFILLER_36_777 VPWR VGND sg13g2_decap_8
XFILLER_35_298 VPWR VGND sg13g2_decap_8
X_2915_ net148 VGND VPWR _0072_ falutop.div_inst.rem\[1\] clknet_4_6_0_clk sg13g2_dfrbpq_2
XFILLER_31_460 VPWR VGND sg13g2_fill_1
X_2846_ net99 VGND VPWR net183 falutop.div_inst.quo\[4\] clknet_4_5_0_clk sg13g2_dfrbpq_1
XFILLER_31_482 VPWR VGND sg13g2_decap_8
Xhold100 falutop.i2c_inst.result\[0\] VPWR VGND net274 sg13g2_dlygate4sd3_1
X_2777_ _1116_ _0757_ _1041_ VPWR VGND sg13g2_nand2_1
X_1728_ _0750_ _0761_ _0209_ VPWR VGND sg13g2_nor2_1
Xhold122 falutop.alu_data_in\[9\] VPWR VGND net429 sg13g2_dlygate4sd3_1
Xhold111 falutop.div_inst.rem\[1\] VPWR VGND net418 sg13g2_dlygate4sd3_1
X_2944__79 VPWR VGND net79 sg13g2_tiehi
X_1659_ _1284_ _1339_ _1282_ _1342_ VPWR VGND sg13g2_nand3_1
XFILLER_37_14 VPWR VGND sg13g2_decap_8
XFILLER_27_722 VPWR VGND sg13g2_fill_1
XFILLER_14_427 VPWR VGND sg13g2_fill_1
XFILLER_26_287 VPWR VGND sg13g2_decap_8
XFILLER_27_799 VPWR VGND sg13g2_decap_8
XFILLER_30_909 VPWR VGND sg13g2_decap_8
XFILLER_22_471 VPWR VGND sg13g2_fill_1
XFILLER_6_615 VPWR VGND sg13g2_decap_8
XFILLER_10_666 VPWR VGND sg13g2_decap_8
XFILLER_5_114 VPWR VGND sg13g2_fill_1
XFILLER_2_854 VPWR VGND sg13g2_decap_8
XFILLER_1_364 VPWR VGND sg13g2_decap_8
XFILLER_49_346 VPWR VGND sg13g2_decap_8
XFILLER_49_379 VPWR VGND sg13g2_decap_8
XFILLER_17_221 VPWR VGND sg13g2_fill_1
XFILLER_18_766 VPWR VGND sg13g2_fill_1
XFILLER_27_91 VPWR VGND sg13g2_decap_8
XFILLER_14_950 VPWR VGND sg13g2_decap_8
XFILLER_32_224 VPWR VGND sg13g2_fill_2
XFILLER_32_246 VPWR VGND sg13g2_decap_8
XFILLER_32_257 VPWR VGND sg13g2_fill_1
XFILLER_32_268 VPWR VGND sg13g2_decap_8
X_2700_ net380 falutop.alu_inst.op\[0\] _1040_ VPWR VGND sg13g2_nor2_1
XFILLER_9_497 VPWR VGND sg13g2_decap_8
X_2631_ _0969_ _0970_ _0971_ VPWR VGND sg13g2_and2_1
X_2562_ net231 _0925_ _0929_ VPWR VGND sg13g2_nor2_1
XFILLER_5_681 VPWR VGND sg13g2_decap_8
X_1513_ VGND VPWR _0763_ net279 _1198_ net285 sg13g2_a21oi_1
X_2493_ VGND VPWR _0875_ _0879_ _0024_ _0887_ sg13g2_a21oi_1
XFILLER_24_703 VPWR VGND sg13g2_decap_8
XFILLER_23_224 VPWR VGND sg13g2_decap_8
XFILLER_11_419 VPWR VGND sg13g2_decap_4
XFILLER_23_16 VPWR VGND sg13g2_decap_8
XFILLER_20_964 VPWR VGND sg13g2_decap_8
X_2829_ _1167_ _1163_ _1165_ VPWR VGND sg13g2_xnor2_1
XFILLER_2_139 VPWR VGND sg13g2_decap_8
Xfanout410 rst_n net410 VPWR VGND sg13g2_buf_8
XFILLER_48_35 VPWR VGND sg13g2_fill_1
XFILLER_27_541 VPWR VGND sg13g2_decap_8
XFILLER_27_563 VPWR VGND sg13g2_fill_1
XFILLER_42_511 VPWR VGND sg13g2_decap_8
XFILLER_27_585 VPWR VGND sg13g2_decap_8
XFILLER_30_728 VPWR VGND sg13g2_decap_8
XFILLER_11_953 VPWR VGND sg13g2_decap_8
XFILLER_10_463 VPWR VGND sg13g2_decap_8
XFILLER_7_968 VPWR VGND sg13g2_decap_8
XFILLER_13_71 VPWR VGND sg13g2_decap_8
XFILLER_6_489 VPWR VGND sg13g2_decap_8
XFILLER_2_651 VPWR VGND sg13g2_decap_8
XFILLER_49_121 VPWR VGND sg13g2_decap_8
XFILLER_38_828 VPWR VGND sg13g2_fill_1
XFILLER_38_817 VPWR VGND sg13g2_decap_8
XFILLER_49_198 VPWR VGND sg13g2_decap_8
XFILLER_46_883 VPWR VGND sg13g2_decap_8
XFILLER_33_522 VPWR VGND sg13g2_fill_2
XFILLER_45_393 VPWR VGND sg13g2_decap_8
XFILLER_20_205 VPWR VGND sg13g2_decap_8
XFILLER_33_588 VPWR VGND sg13g2_decap_8
X_1993_ net339 net356 _0469_ VPWR VGND sg13g2_nor2b_2
XFILLER_9_250 VPWR VGND sg13g2_decap_8
X_2614_ net336 net362 _0954_ VPWR VGND sg13g2_nor2_2
XFILLER_47_1015 VPWR VGND sg13g2_decap_8
X_2545_ VGND VPWR _0909_ _0918_ _0044_ _0919_ sg13g2_a21oi_1
X_2476_ _0874_ _0741_ _0872_ VPWR VGND sg13g2_xnor2_1
XFILLER_18_49 VPWR VGND sg13g2_decap_8
XFILLER_44_809 VPWR VGND sg13g2_decap_8
XFILLER_28_349 VPWR VGND sg13g2_decap_8
XFILLER_37_894 VPWR VGND sg13g2_decap_8
XFILLER_36_371 VPWR VGND sg13g2_decap_8
XFILLER_24_599 VPWR VGND sg13g2_fill_2
XFILLER_11_249 VPWR VGND sg13g2_fill_1
Xclkload3 clknet_4_4_0_clk clkload3/X VPWR VGND sg13g2_buf_1
XFILLER_4_916 VPWR VGND sg13g2_decap_8
XFILLER_3_459 VPWR VGND sg13g2_decap_8
XFILLER_46_113 VPWR VGND sg13g2_decap_8
Xfanout284 _1027_ net284 VPWR VGND sg13g2_buf_8
Xfanout295 _0923_ net295 VPWR VGND sg13g2_buf_8
XFILLER_43_864 VPWR VGND sg13g2_decap_8
XFILLER_42_352 VPWR VGND sg13g2_decap_8
XFILLER_15_555 VPWR VGND sg13g2_decap_8
XFILLER_30_503 VPWR VGND sg13g2_decap_8
XFILLER_30_547 VPWR VGND sg13g2_decap_8
XFILLER_11_750 VPWR VGND sg13g2_decap_8
XFILLER_7_765 VPWR VGND sg13g2_decap_8
XFILLER_6_275 VPWR VGND sg13g2_decap_8
XFILLER_40_91 VPWR VGND sg13g2_decap_8
X_2330_ net351 _0749_ VPWR VGND sg13g2_inv_4
X_2261_ net403 VPWR _0696_ VGND falutop.i2c_inst.data_in\[3\] _0695_ sg13g2_o21ai_1
XFILLER_37_113 VPWR VGND sg13g2_decap_8
X_2192_ VGND VPWR net324 net298 _0111_ _0646_ sg13g2_a21oi_1
XFILLER_37_135 VPWR VGND sg13g2_decap_8
XFILLER_37_168 VPWR VGND sg13g2_decap_8
XFILLER_18_360 VPWR VGND sg13g2_decap_8
XFILLER_25_308 VPWR VGND sg13g2_decap_8
XFILLER_34_842 VPWR VGND sg13g2_decap_8
XFILLER_21_503 VPWR VGND sg13g2_fill_2
XFILLER_33_374 VPWR VGND sg13g2_decap_8
XFILLER_33_385 VPWR VGND sg13g2_fill_1
X_1976_ net381 VPWR _0453_ VGND falutop.div_inst.rem\[1\] falutop.div_inst.rem\[0\]
+ sg13g2_o21ai_1
XFILLER_21_569 VPWR VGND sg13g2_fill_2
XFILLER_0_407 VPWR VGND sg13g2_decap_8
X_2528_ _0903_ _0883_ falutop.i2c_inst.result\[4\] _0882_ falutop.i2c_inst.result\[5\]
+ VPWR VGND sg13g2_a22oi_1
X_2459_ VGND VPWR _0745_ net322 _0019_ _0858_ sg13g2_a21oi_1
Xhold37 falutop.div_inst.acc\[3\] VPWR VGND net211 sg13g2_dlygate4sd3_1
Xhold15 _0000_ VPWR VGND net189 sg13g2_dlygate4sd3_1
Xhold26 falutop.div_inst.a\[5\] VPWR VGND net200 sg13g2_dlygate4sd3_1
Xhold59 _0052_ VPWR VGND net233 sg13g2_dlygate4sd3_1
Xhold48 falutop.div_inst.quo\[0\] VPWR VGND net222 sg13g2_dlygate4sd3_1
XFILLER_29_614 VPWR VGND sg13g2_decap_8
XFILLER_29_636 VPWR VGND sg13g2_decap_8
XFILLER_29_658 VPWR VGND sg13g2_decap_8
XFILLER_44_639 VPWR VGND sg13g2_decap_8
XFILLER_43_149 VPWR VGND sg13g2_decap_8
XFILLER_25_875 VPWR VGND sg13g2_decap_8
XFILLER_12_547 VPWR VGND sg13g2_decap_8
XFILLER_8_529 VPWR VGND sg13g2_decap_8
X_2922__134 VPWR VGND net134 sg13g2_tiehi
XFILLER_4_713 VPWR VGND sg13g2_decap_8
XFILLER_3_234 VPWR VGND sg13g2_decap_8
XFILLER_10_72 VPWR VGND sg13g2_decap_8
XFILLER_10_83 VPWR VGND sg13g2_fill_2
XFILLER_0_974 VPWR VGND sg13g2_decap_8
XFILLER_48_934 VPWR VGND sg13g2_decap_8
XFILLER_47_455 VPWR VGND sg13g2_decap_4
XFILLER_35_628 VPWR VGND sg13g2_decap_8
XFILLER_16_820 VPWR VGND sg13g2_decap_8
XFILLER_34_116 VPWR VGND sg13g2_decap_8
XFILLER_31_812 VPWR VGND sg13g2_decap_4
XFILLER_42_160 VPWR VGND sg13g2_fill_2
XFILLER_15_374 VPWR VGND sg13g2_decap_8
XFILLER_16_897 VPWR VGND sg13g2_decap_8
XFILLER_31_856 VPWR VGND sg13g2_decap_8
XFILLER_31_878 VPWR VGND sg13g2_decap_8
X_1830_ _0310_ _0243_ _0246_ VPWR VGND sg13g2_nand2_1
XFILLER_30_388 VPWR VGND sg13g2_decap_8
X_1761_ _0177_ _0955_ _0952_ _0242_ VPWR VGND sg13g2_a21o_1
XFILLER_7_562 VPWR VGND sg13g2_decap_8
X_1692_ net336 net362 net280 _0174_ VPWR VGND sg13g2_mux2_1
X_2313_ VPWR _0732_ net237 VGND sg13g2_inv_1
XFILLER_39_945 VPWR VGND sg13g2_decap_8
XFILLER_38_422 VPWR VGND sg13g2_fill_1
Xheichips25_template_17 VPWR VGND uio_out[4] sg13g2_tielo
X_2244_ VGND VPWR net301 _0683_ _0126_ _0681_ sg13g2_a21oi_1
X_2175_ falutop.data_in\[6\] net296 _0638_ VPWR VGND sg13g2_nor2_1
XFILLER_18_0 VPWR VGND sg13g2_fill_2
XFILLER_41_609 VPWR VGND sg13g2_decap_8
XFILLER_40_119 VPWR VGND sg13g2_decap_8
XFILLER_34_683 VPWR VGND sg13g2_decap_8
XFILLER_21_366 VPWR VGND sg13g2_decap_4
XFILLER_21_377 VPWR VGND sg13g2_decap_8
X_1959_ _0434_ _0418_ _0436_ VPWR VGND sg13g2_xor2_1
XFILLER_1_749 VPWR VGND sg13g2_decap_8
XFILLER_0_248 VPWR VGND sg13g2_decap_8
XFILLER_45_926 VPWR VGND sg13g2_decap_8
XFILLER_44_469 VPWR VGND sg13g2_decap_4
XFILLER_44_458 VPWR VGND sg13g2_fill_2
XFILLER_12_311 VPWR VGND sg13g2_decap_8
XFILLER_25_694 VPWR VGND sg13g2_decap_8
XFILLER_9_805 VPWR VGND sg13g2_decap_8
XFILLER_13_856 VPWR VGND sg13g2_decap_8
XFILLER_8_304 VPWR VGND sg13g2_decap_8
XFILLER_12_399 VPWR VGND sg13g2_decap_4
XFILLER_4_510 VPWR VGND sg13g2_decap_8
XFILLER_4_587 VPWR VGND sg13g2_decap_8
XFILLER_39_208 VPWR VGND sg13g2_decap_8
XFILLER_0_771 VPWR VGND sg13g2_decap_8
XFILLER_48_731 VPWR VGND sg13g2_decap_8
XFILLER_47_274 VPWR VGND sg13g2_decap_8
XFILLER_36_937 VPWR VGND sg13g2_decap_8
XFILLER_44_970 VPWR VGND sg13g2_decap_8
XFILLER_16_661 VPWR VGND sg13g2_decap_8
X_2931_ net116 VGND VPWR net258 falutop.i2c_inst.result\[9\] clknet_4_12_0_clk sg13g2_dfrbpq_1
Xclkbuf_0_clk clk clknet_0_clk VPWR VGND sg13g2_buf_8
X_2862_ net75 VGND VPWR _0019_ falutop.i2c_inst.op\[3\] net398 sg13g2_dfrbpq_1
XFILLER_30_141 VPWR VGND sg13g2_decap_4
XFILLER_31_675 VPWR VGND sg13g2_decap_8
X_2793_ _1131_ VPWR _1132_ VGND _1092_ _1098_ sg13g2_o21ai_1
X_1813_ VGND VPWR _0291_ _0292_ _0293_ net293 sg13g2_a21oi_1
X_1744_ _0224_ VPWR _0225_ VGND _0222_ _0223_ sg13g2_o21ai_1
XFILLER_8_893 VPWR VGND sg13g2_decap_8
X_1675_ net366 _0154_ net346 _0157_ VPWR VGND _0155_ sg13g2_nand4_1
XFILLER_39_742 VPWR VGND sg13g2_decap_8
XFILLER_39_731 VPWR VGND sg13g2_decap_4
X_2227_ _0671_ net176 net300 VPWR VGND sg13g2_nand2_1
XFILLER_39_797 VPWR VGND sg13g2_fill_1
XFILLER_39_786 VPWR VGND sg13g2_decap_8
X_2158_ VPWR _0095_ _0628_ VGND sg13g2_inv_1
XFILLER_26_38 VPWR VGND sg13g2_decap_8
XFILLER_26_425 VPWR VGND sg13g2_decap_8
XFILLER_26_447 VPWR VGND sg13g2_decap_8
XFILLER_27_959 VPWR VGND sg13g2_decap_8
X_2089_ _0563_ _0504_ _0561_ VPWR VGND sg13g2_xnor2_1
XFILLER_42_907 VPWR VGND sg13g2_decap_8
XFILLER_13_108 VPWR VGND sg13g2_fill_2
XFILLER_21_141 VPWR VGND sg13g2_fill_1
XFILLER_22_686 VPWR VGND sg13g2_decap_8
XFILLER_10_848 VPWR VGND sg13g2_decap_8
XFILLER_1_546 VPWR VGND sg13g2_decap_8
XFILLER_18_926 VPWR VGND sg13g2_decap_8
XFILLER_29_241 VPWR VGND sg13g2_decap_8
XFILLER_17_447 VPWR VGND sg13g2_decap_8
XFILLER_17_458 VPWR VGND sg13g2_fill_2
XFILLER_33_918 VPWR VGND sg13g2_decap_8
XFILLER_44_288 VPWR VGND sg13g2_decap_8
XFILLER_41_940 VPWR VGND sg13g2_decap_8
XFILLER_9_602 VPWR VGND sg13g2_decap_8
XFILLER_34_1006 VPWR VGND sg13g2_decap_8
XFILLER_13_675 VPWR VGND sg13g2_fill_2
XFILLER_8_123 VPWR VGND sg13g2_fill_1
XFILLER_12_196 VPWR VGND sg13g2_decap_4
XFILLER_8_156 VPWR VGND sg13g2_decap_8
XFILLER_9_679 VPWR VGND sg13g2_decap_8
XFILLER_5_863 VPWR VGND sg13g2_decap_8
X_2012_ VGND VPWR _0750_ net280 _0488_ net285 sg13g2_a21oi_1
XFILLER_35_266 VPWR VGND sg13g2_decap_8
X_2914_ net150 VGND VPWR _0071_ falutop.div_inst.rem\[0\] clknet_4_1_0_clk sg13g2_dfrbpq_2
XFILLER_32_995 VPWR VGND sg13g2_decap_8
X_2845_ net100 VGND VPWR net191 falutop.div_inst.quo\[3\] clknet_4_4_0_clk sg13g2_dfrbpq_1
XFILLER_12_29 VPWR VGND sg13g2_fill_1
XFILLER_8_690 VPWR VGND sg13g2_decap_8
Xhold101 _0079_ VPWR VGND net275 sg13g2_dlygate4sd3_1
X_2776_ _0757_ _1041_ _1115_ VPWR VGND sg13g2_and2_1
Xhold123 falutop.alu_data_in\[0\] VPWR VGND net430 sg13g2_dlygate4sd3_1
Xhold112 _0942_ VPWR VGND net419 sg13g2_dlygate4sd3_1
X_1727_ _0207_ _0204_ _0208_ VPWR VGND sg13g2_xor2_1
X_1658_ VPWR _1341_ _1340_ VGND sg13g2_inv_1
X_1589_ _1273_ _1270_ _1271_ VPWR VGND sg13g2_xnor2_1
XFILLER_27_701 VPWR VGND sg13g2_decap_8
XFILLER_39_594 VPWR VGND sg13g2_fill_2
XFILLER_39_572 VPWR VGND sg13g2_decap_8
XFILLER_2_1015 VPWR VGND sg13g2_decap_8
XFILLER_42_704 VPWR VGND sg13g2_decap_4
XFILLER_27_767 VPWR VGND sg13g2_decap_8
XFILLER_41_203 VPWR VGND sg13g2_decap_8
XFILLER_26_266 VPWR VGND sg13g2_decap_8
XFILLER_10_645 VPWR VGND sg13g2_decap_8
XFILLER_23_995 VPWR VGND sg13g2_decap_8
XFILLER_2_833 VPWR VGND sg13g2_decap_8
XFILLER_49_325 VPWR VGND sg13g2_decap_8
XFILLER_49_358 VPWR VGND sg13g2_decap_8
XFILLER_40_1010 VPWR VGND sg13g2_decap_8
XFILLER_17_266 VPWR VGND sg13g2_decap_4
XFILLER_32_203 VPWR VGND sg13g2_decap_8
XFILLER_33_759 VPWR VGND sg13g2_decap_8
XFILLER_9_476 VPWR VGND sg13g2_decap_8
X_2630_ VGND VPWR _0970_ net371 net348 sg13g2_or2_1
X_2561_ net198 _0927_ _0928_ VPWR VGND sg13g2_nor2_1
X_2492_ net404 VPWR _0887_ VGND falutop.i2c_inst.counter\[2\] net286 sg13g2_o21ai_1
XFILLER_5_660 VPWR VGND sg13g2_decap_8
X_1512_ _1196_ _1197_ _0081_ VPWR VGND sg13g2_nor2_1
XFILLER_49_881 VPWR VGND sg13g2_decap_8
X_2847__98 VPWR VGND net98 sg13g2_tiehi
XFILLER_23_203 VPWR VGND sg13g2_decap_8
XFILLER_36_575 VPWR VGND sg13g2_decap_4
XFILLER_24_759 VPWR VGND sg13g2_decap_8
XFILLER_20_943 VPWR VGND sg13g2_decap_8
X_2828_ _1163_ _1165_ _1166_ VPWR VGND sg13g2_nor2b_1
X_2759_ _1095_ VPWR _1098_ VGND _1032_ _1097_ sg13g2_o21ai_1
XFILLER_2_118 VPWR VGND sg13g2_decap_8
XFILLER_48_14 VPWR VGND sg13g2_decap_8
Xfanout400 net404 net400 VPWR VGND sg13g2_buf_8
XFILLER_48_47 VPWR VGND sg13g2_decap_8
X_2988__137 VPWR VGND net137 sg13g2_tiehi
XFILLER_27_520 VPWR VGND sg13g2_decap_8
XFILLER_15_704 VPWR VGND sg13g2_fill_2
XFILLER_14_214 VPWR VGND sg13g2_decap_8
XFILLER_42_567 VPWR VGND sg13g2_fill_1
XFILLER_11_932 VPWR VGND sg13g2_decap_8
XFILLER_23_781 VPWR VGND sg13g2_decap_8
XFILLER_10_453 VPWR VGND sg13g2_fill_1
XFILLER_13_50 VPWR VGND sg13g2_decap_8
XFILLER_7_947 VPWR VGND sg13g2_decap_8
XFILLER_6_424 VPWR VGND sg13g2_fill_2
XFILLER_6_468 VPWR VGND sg13g2_decap_8
XFILLER_2_630 VPWR VGND sg13g2_decap_8
XFILLER_49_100 VPWR VGND sg13g2_decap_8
X_2932__114 VPWR VGND net114 sg13g2_tiehi
XFILLER_49_177 VPWR VGND sg13g2_decap_8
XFILLER_37_328 VPWR VGND sg13g2_decap_4
XFILLER_37_317 VPWR VGND sg13g2_fill_2
XFILLER_46_862 VPWR VGND sg13g2_decap_8
XFILLER_45_372 VPWR VGND sg13g2_decap_8
XFILLER_33_545 VPWR VGND sg13g2_fill_2
XFILLER_33_556 VPWR VGND sg13g2_decap_8
X_1992_ _0468_ net335 net359 VPWR VGND sg13g2_nand2_1
XFILLER_9_284 VPWR VGND sg13g2_decap_8
Xclkload10 VPWR clkload10/Y clknet_4_12_0_clk VGND sg13g2_inv_1
X_2613_ _0953_ net338 net360 VPWR VGND sg13g2_nand2_2
X_2544_ net403 VPWR _0919_ VGND falutop.i2c_inst.sda_o _0867_ sg13g2_o21ai_1
XFILLER_48_0 VPWR VGND sg13g2_decap_8
X_2475_ falutop.i2c_inst.counter\[2\] falutop.i2c_inst.counter\[1\] falutop.i2c_inst.counter\[0\]
+ _0873_ VPWR VGND sg13g2_nor3_1
XFILLER_29_807 VPWR VGND sg13g2_fill_2
XFILLER_29_818 VPWR VGND sg13g2_decap_8
XFILLER_37_873 VPWR VGND sg13g2_decap_8
Xclkload4 VPWR clkload4/Y clknet_4_5_0_clk VGND sg13g2_inv_1
XFILLER_20_762 VPWR VGND sg13g2_fill_2
XFILLER_20_795 VPWR VGND sg13g2_decap_8
XFILLER_3_438 VPWR VGND sg13g2_decap_8
Xfanout296 net297 net296 VPWR VGND sg13g2_buf_8
Xfanout285 _0995_ net285 VPWR VGND sg13g2_buf_8
XFILLER_46_147 VPWR VGND sg13g2_decap_8
XFILLER_46_169 VPWR VGND sg13g2_decap_8
XFILLER_15_501 VPWR VGND sg13g2_decap_8
XFILLER_27_350 VPWR VGND sg13g2_decap_8
XFILLER_27_361 VPWR VGND sg13g2_fill_1
XFILLER_28_895 VPWR VGND sg13g2_decap_8
XFILLER_43_843 VPWR VGND sg13g2_decap_8
XFILLER_42_331 VPWR VGND sg13g2_decap_8
XFILLER_42_386 VPWR VGND sg13g2_decap_8
XFILLER_7_744 VPWR VGND sg13g2_decap_8
XFILLER_40_70 VPWR VGND sg13g2_decap_8
X_2260_ _0863_ _0685_ _0695_ VPWR VGND sg13g2_nor2_1
XFILLER_38_637 VPWR VGND sg13g2_fill_2
XFILLER_38_626 VPWR VGND sg13g2_decap_8
XFILLER_38_615 VPWR VGND sg13g2_decap_4
X_2191_ falutop.data_in\[14\] net298 _0646_ VPWR VGND sg13g2_nor2_1
XFILLER_37_147 VPWR VGND sg13g2_decap_8
XFILLER_1_42 VPWR VGND sg13g2_decap_8
XFILLER_19_884 VPWR VGND sg13g2_decap_8
XFILLER_18_394 VPWR VGND sg13g2_decap_8
XFILLER_33_353 VPWR VGND sg13g2_decap_8
XFILLER_34_887 VPWR VGND sg13g2_decap_8
XFILLER_21_548 VPWR VGND sg13g2_fill_2
X_1975_ _0449_ _0451_ _0359_ _0452_ VPWR VGND sg13g2_nand3_1
XFILLER_20_18 VPWR VGND sg13g2_decap_8
X_2527_ falutop.i2c_inst.counter\[1\] falutop.i2c_inst.counter\[0\] _0902_ VPWR VGND
+ sg13g2_and2_1
X_2458_ falutop.i2c_inst.data_in\[19\] net322 _0858_ VPWR VGND sg13g2_nor2_1
Xhold38 _0010_ VPWR VGND net212 sg13g2_dlygate4sd3_1
Xhold16 falutop.div_inst.quo\[3\] VPWR VGND net190 sg13g2_dlygate4sd3_1
Xhold27 falutop.div_inst.a\[1\] VPWR VGND net201 sg13g2_dlygate4sd3_1
Xhold49 _0920_ VPWR VGND net223 sg13g2_dlygate4sd3_1
X_2389_ VGND VPWR net287 _0799_ _0007_ _0800_ sg13g2_a21oi_1
XFILLER_28_114 VPWR VGND sg13g2_fill_1
XFILLER_29_626 VPWR VGND sg13g2_decap_4
XFILLER_44_618 VPWR VGND sg13g2_decap_8
XFILLER_43_106 VPWR VGND sg13g2_decap_8
XFILLER_40_802 VPWR VGND sg13g2_decap_4
XFILLER_12_526 VPWR VGND sg13g2_decap_8
XFILLER_24_364 VPWR VGND sg13g2_fill_2
XFILLER_8_508 VPWR VGND sg13g2_decap_8
XFILLER_3_213 VPWR VGND sg13g2_decap_8
XFILLER_10_40 VPWR VGND sg13g2_decap_4
XFILLER_4_769 VPWR VGND sg13g2_decap_8
XFILLER_48_913 VPWR VGND sg13g2_decap_8
XFILLER_0_953 VPWR VGND sg13g2_decap_8
XFILLER_19_114 VPWR VGND sg13g2_decap_4
XFILLER_47_434 VPWR VGND sg13g2_decap_8
XFILLER_15_320 VPWR VGND sg13g2_fill_1
XFILLER_27_180 VPWR VGND sg13g2_decap_8
XFILLER_43_662 VPWR VGND sg13g2_decap_4
XFILLER_15_353 VPWR VGND sg13g2_decap_8
XFILLER_16_876 VPWR VGND sg13g2_decap_8
XFILLER_43_695 VPWR VGND sg13g2_fill_2
XFILLER_31_835 VPWR VGND sg13g2_decap_8
XFILLER_42_183 VPWR VGND sg13g2_fill_2
XFILLER_30_323 VPWR VGND sg13g2_decap_8
X_1760_ _0982_ _0951_ _0241_ VPWR VGND sg13g2_xor2_1
XFILLER_7_541 VPWR VGND sg13g2_decap_8
X_1691_ _0172_ VPWR _0173_ VGND _1316_ _0171_ sg13g2_o21ai_1
X_2312_ _0731_ net3 VPWR VGND sg13g2_inv_2
XFILLER_44_1019 VPWR VGND sg13g2_decap_8
XFILLER_39_924 VPWR VGND sg13g2_decap_8
Xheichips25_template_18 VPWR VGND uio_out[5] sg13g2_tielo
X_2243_ _0682_ falutop.data_in\[14\] _0683_ VPWR VGND sg13g2_xor2_1
X_2174_ falutop.data_in\[5\] net362 net297 _0102_ VPWR VGND sg13g2_mux2_1
XFILLER_38_489 VPWR VGND sg13g2_fill_1
XFILLER_19_670 VPWR VGND sg13g2_decap_8
XFILLER_18_180 VPWR VGND sg13g2_decap_8
XFILLER_21_345 VPWR VGND sg13g2_fill_2
XFILLER_22_879 VPWR VGND sg13g2_decap_8
X_1958_ _0418_ _0434_ _0435_ VPWR VGND sg13g2_nor2_1
X_1889_ _0330_ VPWR _0367_ VGND _0325_ _0331_ sg13g2_o21ai_1
XFILLER_0_227 VPWR VGND sg13g2_decap_8
XFILLER_1_728 VPWR VGND sg13g2_decap_8
XFILLER_5_1024 VPWR VGND sg13g2_decap_4
XFILLER_45_905 VPWR VGND sg13g2_decap_8
XFILLER_44_426 VPWR VGND sg13g2_decap_8
XFILLER_16_139 VPWR VGND sg13g2_fill_1
XFILLER_25_651 VPWR VGND sg13g2_decap_8
XFILLER_13_835 VPWR VGND sg13g2_decap_8
XFILLER_40_632 VPWR VGND sg13g2_decap_8
XFILLER_12_345 VPWR VGND sg13g2_decap_8
XFILLER_40_676 VPWR VGND sg13g2_decap_8
XFILLER_12_378 VPWR VGND sg13g2_decap_8
XFILLER_21_890 VPWR VGND sg13g2_decap_8
XFILLER_4_566 VPWR VGND sg13g2_decap_8
XFILLER_0_750 VPWR VGND sg13g2_decap_8
XFILLER_48_710 VPWR VGND sg13g2_decap_8
XFILLER_48_787 VPWR VGND sg13g2_decap_8
XFILLER_36_916 VPWR VGND sg13g2_decap_8
XFILLER_16_640 VPWR VGND sg13g2_decap_8
XFILLER_35_459 VPWR VGND sg13g2_fill_1
X_2930_ net118 VGND VPWR net256 falutop.i2c_inst.result\[8\] clknet_4_13_0_clk sg13g2_dfrbpq_1
X_2861_ net76 VGND VPWR _0018_ falutop.i2c_inst.op\[2\] net398 sg13g2_dfrbpq_1
XFILLER_31_687 VPWR VGND sg13g2_decap_8
X_2792_ _1107_ _1111_ _1122_ _1130_ _1131_ VPWR VGND sg13g2_nor4_1
X_1812_ VGND VPWR _0222_ _0223_ _0292_ _0221_ sg13g2_a21oi_1
XFILLER_30_186 VPWR VGND sg13g2_fill_1
XFILLER_8_872 VPWR VGND sg13g2_decap_8
X_1743_ VGND VPWR _0222_ _0223_ _0224_ net293 sg13g2_a21oi_1
XFILLER_7_393 VPWR VGND sg13g2_decap_8
XFILLER_7_85 VPWR VGND sg13g2_fill_2
X_1674_ net346 net366 _0154_ _0155_ _0156_ VPWR VGND sg13g2_and4_1
XFILLER_39_710 VPWR VGND sg13g2_decap_8
X_2226_ _0669_ falutop.data_in\[10\] _0670_ VPWR VGND sg13g2_xor2_1
X_2157_ _0628_ _0627_ net383 net299 net241 VPWR VGND sg13g2_a22oi_1
XFILLER_27_938 VPWR VGND sg13g2_decap_8
X_2088_ _0562_ _0561_ _0504_ VPWR VGND sg13g2_nand2b_1
XFILLER_34_481 VPWR VGND sg13g2_decap_8
XFILLER_10_827 VPWR VGND sg13g2_decap_8
XFILLER_22_665 VPWR VGND sg13g2_decap_8
XFILLER_1_525 VPWR VGND sg13g2_decap_8
XFILLER_29_220 VPWR VGND sg13g2_decap_8
XFILLER_45_713 VPWR VGND sg13g2_decap_4
XFILLER_18_905 VPWR VGND sg13g2_decap_8
XFILLER_44_212 VPWR VGND sg13g2_decap_8
XFILLER_17_415 VPWR VGND sg13g2_decap_8
XFILLER_29_297 VPWR VGND sg13g2_decap_8
XFILLER_45_779 VPWR VGND sg13g2_decap_8
XFILLER_16_50 VPWR VGND sg13g2_fill_1
XFILLER_13_621 VPWR VGND sg13g2_fill_1
XFILLER_13_643 VPWR VGND sg13g2_decap_4
XFILLER_16_72 VPWR VGND sg13g2_decap_4
XFILLER_16_83 VPWR VGND sg13g2_decap_8
XFILLER_25_481 VPWR VGND sg13g2_decap_8
XFILLER_8_102 VPWR VGND sg13g2_decap_8
XFILLER_41_996 VPWR VGND sg13g2_decap_8
XFILLER_9_658 VPWR VGND sg13g2_decap_8
XFILLER_5_842 VPWR VGND sg13g2_decap_8
XFILLER_4_352 VPWR VGND sg13g2_fill_2
XFILLER_4_330 VPWR VGND sg13g2_fill_1
XFILLER_48_562 VPWR VGND sg13g2_decap_4
X_2011_ _0487_ _0457_ _0486_ VPWR VGND sg13g2_xnor2_1
XFILLER_48_584 VPWR VGND sg13g2_fill_1
XFILLER_36_713 VPWR VGND sg13g2_fill_1
XFILLER_24_919 VPWR VGND sg13g2_decap_8
XFILLER_35_245 VPWR VGND sg13g2_decap_8
XFILLER_17_982 VPWR VGND sg13g2_decap_8
X_2913_ net152 VGND VPWR _0070_ falutop.div_inst.val\[7\] clknet_4_7_0_clk sg13g2_dfrbpq_1
XFILLER_31_451 VPWR VGND sg13g2_decap_8
XFILLER_32_974 VPWR VGND sg13g2_decap_8
X_2844_ net101 VGND VPWR net194 falutop.div_inst.quo\[2\] clknet_4_4_0_clk sg13g2_dfrbpq_1
X_2775_ net292 _1112_ _1113_ _1114_ VPWR VGND sg13g2_nor3_1
Xhold102 falutop.alu_inst.op\[3\] VPWR VGND net276 sg13g2_dlygate4sd3_1
Xhold113 falutop.div_inst.rem\[0\] VPWR VGND net420 sg13g2_dlygate4sd3_1
Xhold124 falutop.alu_data_in\[10\] VPWR VGND net431 sg13g2_dlygate4sd3_1
X_1726_ _0205_ _1328_ _0207_ VPWR VGND sg13g2_xor2_1
X_1657_ _1284_ _1282_ _1339_ _1340_ VPWR VGND sg13g2_a21o_1
X_1588_ _1272_ _1271_ _1270_ VPWR VGND sg13g2_nand2b_1
X_2209_ _0630_ net384 _0658_ VPWR VGND sg13g2_nor2b_1
XFILLER_15_919 VPWR VGND sg13g2_decap_8
XFILLER_26_245 VPWR VGND sg13g2_decap_8
XFILLER_27_746 VPWR VGND sg13g2_decap_8
XFILLER_42_738 VPWR VGND sg13g2_decap_8
XFILLER_41_237 VPWR VGND sg13g2_decap_8
XFILLER_22_462 VPWR VGND sg13g2_decap_8
XFILLER_23_974 VPWR VGND sg13g2_decap_8
XFILLER_10_624 VPWR VGND sg13g2_decap_8
XFILLER_5_149 VPWR VGND sg13g2_decap_4
XFILLER_2_812 VPWR VGND sg13g2_decap_8
X_2943__81 VPWR VGND net81 sg13g2_tiehi
XFILLER_2_889 VPWR VGND sg13g2_decap_8
XFILLER_1_399 VPWR VGND sg13g2_decap_8
XFILLER_45_510 VPWR VGND sg13g2_fill_2
XFILLER_17_212 VPWR VGND sg13g2_fill_1
XFILLER_18_735 VPWR VGND sg13g2_fill_1
XFILLER_17_245 VPWR VGND sg13g2_decap_8
XFILLER_18_757 VPWR VGND sg13g2_decap_8
XFILLER_45_576 VPWR VGND sg13g2_decap_4
X_2965__149 VPWR VGND net149 sg13g2_tiehi
XFILLER_33_716 VPWR VGND sg13g2_decap_8
XFILLER_33_738 VPWR VGND sg13g2_fill_2
XFILLER_32_226 VPWR VGND sg13g2_fill_1
XFILLER_13_440 VPWR VGND sg13g2_decap_8
XFILLER_14_985 VPWR VGND sg13g2_decap_8
XFILLER_43_70 VPWR VGND sg13g2_decap_8
XFILLER_13_462 VPWR VGND sg13g2_fill_2
XFILLER_40_281 VPWR VGND sg13g2_decap_8
Xheichips25_template_5 VPWR VGND uio_oe[0] sg13g2_tielo
X_2560_ _0927_ net231 _0925_ VPWR VGND sg13g2_nand2_1
X_2491_ VGND VPWR net286 _0885_ _0023_ _0886_ sg13g2_a21oi_1
X_1511_ net405 VPWR _1197_ VGND net268 net305 sg13g2_o21ai_1
XFILLER_4_171 VPWR VGND sg13g2_decap_8
XFILLER_49_860 VPWR VGND sg13g2_decap_8
XFILLER_36_554 VPWR VGND sg13g2_fill_2
XFILLER_24_738 VPWR VGND sg13g2_decap_8
XFILLER_17_1024 VPWR VGND sg13g2_decap_4
XFILLER_23_259 VPWR VGND sg13g2_decap_8
XFILLER_20_922 VPWR VGND sg13g2_decap_8
XFILLER_32_782 VPWR VGND sg13g2_decap_8
X_2827_ _1165_ _0973_ _1150_ VPWR VGND sg13g2_xnor2_1
XFILLER_20_999 VPWR VGND sg13g2_decap_8
X_2758_ net326 _1022_ _1027_ _1031_ _1097_ VPWR VGND sg13g2_nor4_1
XFILLER_2_108 VPWR VGND sg13g2_fill_1
X_1709_ net407 VPWR _0190_ VGND net264 net304 sg13g2_o21ai_1
X_2689_ _1028_ VPWR _1029_ VGND net325 net284 sg13g2_o21ai_1
Xfanout401 net402 net401 VPWR VGND sg13g2_buf_8
XFILLER_24_1017 VPWR VGND sg13g2_decap_8
XFILLER_47_819 VPWR VGND sg13g2_decap_8
XFILLER_24_1028 VPWR VGND sg13g2_fill_1
XFILLER_39_392 VPWR VGND sg13g2_decap_8
XFILLER_42_546 VPWR VGND sg13g2_decap_8
XFILLER_11_911 VPWR VGND sg13g2_decap_8
XFILLER_7_926 VPWR VGND sg13g2_decap_8
XFILLER_11_988 VPWR VGND sg13g2_decap_8
XFILLER_1_130 VPWR VGND sg13g2_fill_1
XFILLER_2_686 VPWR VGND sg13g2_decap_8
XFILLER_49_156 VPWR VGND sg13g2_decap_8
XFILLER_46_841 VPWR VGND sg13g2_decap_8
XFILLER_45_351 VPWR VGND sg13g2_fill_2
XFILLER_45_340 VPWR VGND sg13g2_decap_8
XFILLER_18_587 VPWR VGND sg13g2_decap_8
XFILLER_33_524 VPWR VGND sg13g2_fill_1
X_1991_ _0428_ VPWR _0467_ VGND _0424_ _0429_ sg13g2_o21ai_1
XFILLER_14_782 VPWR VGND sg13g2_decap_8
Xclkload11 VPWR clkload11/Y clknet_4_13_0_clk VGND sg13g2_inv_1
X_2612_ net338 net360 _0952_ VPWR VGND sg13g2_and2_1
X_2543_ VPWR _0918_ _0917_ VGND sg13g2_inv_1
X_2474_ falutop.i2c_inst.counter\[1\] falutop.i2c_inst.counter\[0\] _0872_ VPWR VGND
+ sg13g2_nor2_2
XFILLER_28_307 VPWR VGND sg13g2_decap_8
XFILLER_28_329 VPWR VGND sg13g2_fill_2
XFILLER_37_852 VPWR VGND sg13g2_decap_8
XFILLER_24_546 VPWR VGND sg13g2_fill_2
XFILLER_34_28 VPWR VGND sg13g2_decap_8
XFILLER_12_708 VPWR VGND sg13g2_decap_8
XFILLER_24_568 VPWR VGND sg13g2_decap_4
XFILLER_34_39 VPWR VGND sg13g2_fill_1
XFILLER_11_207 VPWR VGND sg13g2_decap_8
Xclkload5 VPWR clkload5/Y clknet_4_6_0_clk VGND sg13g2_inv_1
XFILLER_30_1021 VPWR VGND sg13g2_decap_8
XFILLER_3_417 VPWR VGND sg13g2_decap_8
XFILLER_1_7 VPWR VGND sg13g2_decap_8
XFILLER_47_616 VPWR VGND sg13g2_decap_8
Xfanout297 net298 net297 VPWR VGND sg13g2_buf_8
Xfanout286 _0879_ net286 VPWR VGND sg13g2_buf_8
XFILLER_28_841 VPWR VGND sg13g2_decap_8
XFILLER_43_822 VPWR VGND sg13g2_decap_8
XFILLER_42_310 VPWR VGND sg13g2_decap_8
XFILLER_27_384 VPWR VGND sg13g2_decap_8
XFILLER_15_546 VPWR VGND sg13g2_decap_4
XFILLER_43_899 VPWR VGND sg13g2_decap_8
XFILLER_42_398 VPWR VGND sg13g2_decap_4
XFILLER_30_538 VPWR VGND sg13g2_decap_4
XFILLER_7_723 VPWR VGND sg13g2_decap_8
XFILLER_11_785 VPWR VGND sg13g2_decap_8
XFILLER_10_284 VPWR VGND sg13g2_fill_2
XFILLER_6_244 VPWR VGND sg13g2_decap_8
XFILLER_3_984 VPWR VGND sg13g2_decap_8
XFILLER_2_483 VPWR VGND sg13g2_decap_8
XFILLER_34_7 VPWR VGND sg13g2_decap_8
X_2190_ VGND VPWR _0752_ net297 _0110_ _0645_ sg13g2_a21oi_1
XFILLER_1_21 VPWR VGND sg13g2_decap_8
XFILLER_18_340 VPWR VGND sg13g2_decap_4
XFILLER_19_863 VPWR VGND sg13g2_decap_8
XFILLER_45_181 VPWR VGND sg13g2_decap_8
XFILLER_34_822 VPWR VGND sg13g2_decap_8
XFILLER_33_332 VPWR VGND sg13g2_decap_8
XFILLER_21_505 VPWR VGND sg13g2_fill_1
X_1974_ _0450_ VPWR _0451_ VGND net371 net278 sg13g2_o21ai_1
XFILLER_14_1027 VPWR VGND sg13g2_fill_2
X_2526_ falutop.i2c_inst.data_in\[15\] net383 net319 _0043_ VPWR VGND sg13g2_mux2_1
X_2457_ VGND VPWR _0746_ net321 _0018_ _0857_ sg13g2_a21oi_1
Xhold28 falutop.div_inst.acc\[4\] VPWR VGND net202 sg13g2_dlygate4sd3_1
Xhold17 _0002_ VPWR VGND net191 sg13g2_dlygate4sd3_1
XFILLER_29_39 VPWR VGND sg13g2_decap_8
Xhold39 falutop.div_inst.acc\[2\] VPWR VGND net213 sg13g2_dlygate4sd3_1
X_2388_ net235 net287 _0800_ VPWR VGND sg13g2_nor2_1
XFILLER_21_1009 VPWR VGND sg13g2_decap_8
XFILLER_25_800 VPWR VGND sg13g2_decap_8
XFILLER_37_693 VPWR VGND sg13g2_decap_8
XFILLER_24_310 VPWR VGND sg13g2_decap_8
XFILLER_25_844 VPWR VGND sg13g2_decap_8
XFILLER_12_505 VPWR VGND sg13g2_decap_8
XFILLER_24_398 VPWR VGND sg13g2_decap_8
XFILLER_4_748 VPWR VGND sg13g2_decap_8
XFILLER_10_96 VPWR VGND sg13g2_fill_2
XFILLER_0_932 VPWR VGND sg13g2_decap_8
XFILLER_47_413 VPWR VGND sg13g2_decap_8
XFILLER_48_969 VPWR VGND sg13g2_decap_8
XFILLER_19_72 VPWR VGND sg13g2_decap_8
XFILLER_19_83 VPWR VGND sg13g2_decap_8
XFILLER_19_137 VPWR VGND sg13g2_fill_2
XFILLER_16_800 VPWR VGND sg13g2_fill_1
XFILLER_19_159 VPWR VGND sg13g2_decap_8
XFILLER_28_660 VPWR VGND sg13g2_fill_1
XFILLER_28_693 VPWR VGND sg13g2_fill_2
XFILLER_34_107 VPWR VGND sg13g2_decap_4
XFILLER_43_641 VPWR VGND sg13g2_decap_8
XFILLER_15_332 VPWR VGND sg13g2_decap_8
XFILLER_16_855 VPWR VGND sg13g2_decap_8
XFILLER_43_674 VPWR VGND sg13g2_decap_8
XFILLER_42_173 VPWR VGND sg13g2_decap_4
XFILLER_37_1027 VPWR VGND sg13g2_fill_2
XFILLER_7_520 VPWR VGND sg13g2_decap_8
X_1690_ VGND VPWR _1316_ _0171_ _0172_ net292 sg13g2_a21oi_1
XFILLER_7_597 VPWR VGND sg13g2_decap_8
X_2311_ VGND VPWR net391 _0729_ _0146_ _0730_ sg13g2_a21oi_1
XFILLER_3_781 VPWR VGND sg13g2_decap_8
XFILLER_39_903 VPWR VGND sg13g2_decap_8
XFILLER_32_4 VPWR VGND sg13g2_decap_4
Xheichips25_template_19 VPWR VGND uio_out[6] sg13g2_tielo
X_2242_ _0682_ net383 _0626_ VPWR VGND sg13g2_nand2_1
XFILLER_18_2 VPWR VGND sg13g2_fill_1
X_2173_ VGND VPWR _0762_ net298 _0101_ _0637_ sg13g2_a21oi_1
XFILLER_20_1020 VPWR VGND sg13g2_decap_8
XFILLER_47_980 VPWR VGND sg13g2_decap_8
XFILLER_19_693 VPWR VGND sg13g2_decap_8
XFILLER_21_324 VPWR VGND sg13g2_decap_8
XFILLER_22_858 VPWR VGND sg13g2_decap_8
XFILLER_33_184 VPWR VGND sg13g2_fill_2
X_1957_ _0434_ _0422_ _0433_ VPWR VGND sg13g2_xnor2_1
XFILLER_31_29 VPWR VGND sg13g2_decap_8
X_1888_ _0365_ _0366_ _0087_ VPWR VGND sg13g2_nor2_1
XFILLER_1_707 VPWR VGND sg13g2_decap_8
X_2509_ _0901_ net406 net316 VPWR VGND sg13g2_nand2_1
XFILLER_5_1003 VPWR VGND sg13g2_decap_8
XFILLER_29_468 VPWR VGND sg13g2_decap_8
XFILLER_40_611 VPWR VGND sg13g2_decap_4
XFILLER_13_814 VPWR VGND sg13g2_decap_8
XFILLER_24_173 VPWR VGND sg13g2_decap_8
XFILLER_40_655 VPWR VGND sg13g2_decap_8
XFILLER_12_357 VPWR VGND sg13g2_decap_8
XFILLER_4_545 VPWR VGND sg13g2_decap_8
XFILLER_48_766 VPWR VGND sg13g2_decap_8
XFILLER_47_243 VPWR VGND sg13g2_decap_8
XFILLER_46_92 VPWR VGND sg13g2_decap_8
XFILLER_28_490 VPWR VGND sg13g2_fill_2
XFILLER_35_449 VPWR VGND sg13g2_fill_2
XFILLER_31_611 VPWR VGND sg13g2_decap_8
X_2860_ net77 VGND VPWR _0017_ falutop.i2c_inst.op\[1\] net398 sg13g2_dfrbpq_2
XFILLER_15_173 VPWR VGND sg13g2_decap_8
X_1811_ _0291_ _0288_ _0289_ VPWR VGND sg13g2_xnor2_1
XFILLER_12_891 VPWR VGND sg13g2_decap_8
X_2791_ _1124_ _1125_ net315 _1130_ VPWR VGND _1129_ sg13g2_nand4_1
XFILLER_30_165 VPWR VGND sg13g2_decap_8
XFILLER_8_851 VPWR VGND sg13g2_decap_8
X_1742_ _0170_ _1315_ _0169_ _0223_ VPWR VGND sg13g2_a21o_1
XFILLER_7_372 VPWR VGND sg13g2_decap_8
XFILLER_7_97 VPWR VGND sg13g2_fill_1
X_1673_ _0151_ VPWR _0155_ VGND _0152_ _0153_ sg13g2_o21ai_1
X_2877__53 VPWR VGND net53 sg13g2_tiehi
X_2225_ net383 VPWR _0669_ VGND falutop.data_in\[8\] falutop.data_in\[9\] sg13g2_o21ai_1
XFILLER_27_917 VPWR VGND sg13g2_decap_8
XFILLER_38_298 VPWR VGND sg13g2_fill_2
X_2156_ falutop.data_in\[14\] net299 _0626_ _0627_ VPWR VGND sg13g2_nor3_1
XFILLER_26_18 VPWR VGND sg13g2_fill_2
X_2087_ _0560_ _0541_ _0561_ VPWR VGND sg13g2_xor2_1
XFILLER_35_983 VPWR VGND sg13g2_decap_8
XFILLER_10_806 VPWR VGND sg13g2_decap_8
XFILLER_21_132 VPWR VGND sg13g2_decap_8
X_2989_ net105 VGND VPWR _0146_ falutop.i2c_inst.data_in\[18\] net398 sg13g2_dfrbpq_1
XFILLER_1_504 VPWR VGND sg13g2_decap_8
XFILLER_27_1015 VPWR VGND sg13g2_decap_8
XFILLER_49_519 VPWR VGND sg13g2_decap_8
X_2868__64 VPWR VGND net64 sg13g2_tiehi
XFILLER_45_703 VPWR VGND sg13g2_fill_2
XFILLER_29_276 VPWR VGND sg13g2_decap_8
XFILLER_45_758 VPWR VGND sg13g2_decap_8
XFILLER_44_257 VPWR VGND sg13g2_fill_2
XFILLER_16_62 VPWR VGND sg13g2_fill_1
XFILLER_26_994 VPWR VGND sg13g2_decap_8
XFILLER_41_975 VPWR VGND sg13g2_decap_8
XFILLER_12_143 VPWR VGND sg13g2_decap_8
XFILLER_9_637 VPWR VGND sg13g2_decap_8
XFILLER_5_821 VPWR VGND sg13g2_decap_8
XFILLER_5_898 VPWR VGND sg13g2_decap_8
X_2010_ _0486_ _0483_ _0485_ VPWR VGND sg13g2_nand2_1
XFILLER_36_703 VPWR VGND sg13g2_fill_2
X_2874__56 VPWR VGND net56 sg13g2_tiehi
XFILLER_35_202 VPWR VGND sg13g2_decap_8
XFILLER_17_961 VPWR VGND sg13g2_decap_8
XFILLER_16_482 VPWR VGND sg13g2_decap_8
X_2912_ net154 VGND VPWR _0069_ falutop.div_inst.val\[6\] clknet_4_7_0_clk sg13g2_dfrbpq_2
X_2981__133 VPWR VGND net133 sg13g2_tiehi
XFILLER_31_430 VPWR VGND sg13g2_decap_8
XFILLER_32_953 VPWR VGND sg13g2_decap_8
X_2843_ net121 VGND VPWR net189 falutop.div_inst.quo\[1\] clknet_4_6_0_clk sg13g2_dfrbpq_1
X_2774_ _1113_ net374 net355 net375 net351 VPWR VGND sg13g2_a22oi_1
X_1725_ net363 _1328_ net348 _0206_ VPWR VGND sg13g2_nand3_1
Xhold114 falutop.alu_inst.op\[0\] VPWR VGND net421 sg13g2_dlygate4sd3_1
XFILLER_7_191 VPWR VGND sg13g2_decap_8
Xhold125 falutop.alu_data_in\[3\] VPWR VGND net432 sg13g2_dlygate4sd3_1
Xhold103 falutop.div_inst.val\[0\] VPWR VGND net277 sg13g2_dlygate4sd3_1
X_1656_ _1339_ _1337_ _1338_ VPWR VGND sg13g2_xnor2_1
X_1587_ _1242_ VPWR _1271_ VGND _1240_ _1243_ sg13g2_o21ai_1
XFILLER_39_530 VPWR VGND sg13g2_fill_2
XFILLER_37_39 VPWR VGND sg13g2_decap_8
XFILLER_37_28 VPWR VGND sg13g2_decap_4
XFILLER_39_596 VPWR VGND sg13g2_fill_1
X_2208_ net228 net303 _0657_ VPWR VGND sg13g2_nor2_1
XFILLER_26_202 VPWR VGND sg13g2_decap_8
XFILLER_26_213 VPWR VGND sg13g2_fill_2
X_2139_ VGND VPWR _0607_ _0610_ _0093_ _0611_ sg13g2_a21oi_1
XFILLER_26_224 VPWR VGND sg13g2_decap_8
XFILLER_22_441 VPWR VGND sg13g2_decap_8
XFILLER_23_953 VPWR VGND sg13g2_decap_8
XFILLER_10_603 VPWR VGND sg13g2_decap_8
XFILLER_22_485 VPWR VGND sg13g2_decap_8
XFILLER_6_629 VPWR VGND sg13g2_decap_8
XFILLER_5_128 VPWR VGND sg13g2_decap_8
XFILLER_2_868 VPWR VGND sg13g2_decap_8
XFILLER_1_378 VPWR VGND sg13g2_decap_8
XFILLER_18_703 VPWR VGND sg13g2_decap_4
XFILLER_17_279 VPWR VGND sg13g2_fill_2
XFILLER_27_83 VPWR VGND sg13g2_decap_4
XFILLER_26_780 VPWR VGND sg13g2_fill_2
X_2871__59 VPWR VGND net59 sg13g2_tiehi
XFILLER_14_964 VPWR VGND sg13g2_decap_8
XFILLER_41_794 VPWR VGND sg13g2_fill_2
XFILLER_41_783 VPWR VGND sg13g2_decap_8
XFILLER_40_260 VPWR VGND sg13g2_decap_8
XFILLER_13_496 VPWR VGND sg13g2_fill_2
Xheichips25_template_6 VPWR VGND uio_oe[1] sg13g2_tielo
X_2490_ net403 VPWR _0886_ VGND falutop.i2c_inst.counter\[1\] net286 sg13g2_o21ai_1
X_1510_ VPWR VGND _1195_ net307 _1194_ net290 _1196_ _1191_ sg13g2_a221oi_1
XFILLER_5_695 VPWR VGND sg13g2_decap_8
XFILLER_4_32 VPWR VGND sg13g2_decap_4
XFILLER_48_382 VPWR VGND sg13g2_fill_1
XFILLER_36_533 VPWR VGND sg13g2_decap_8
XFILLER_24_717 VPWR VGND sg13g2_decap_8
XFILLER_23_238 VPWR VGND sg13g2_decap_8
XFILLER_17_1003 VPWR VGND sg13g2_decap_8
XFILLER_20_901 VPWR VGND sg13g2_decap_8
XFILLER_32_750 VPWR VGND sg13g2_decap_8
X_2826_ VGND VPWR _1164_ _1150_ _0974_ sg13g2_or2_1
XFILLER_20_978 VPWR VGND sg13g2_decap_8
X_2757_ _1022_ _1031_ _1096_ VPWR VGND sg13g2_nor2_2
X_2688_ _1028_ net348 net284 VPWR VGND sg13g2_nand2_1
X_1708_ _1325_ _0189_ _0084_ VPWR VGND sg13g2_nor2_1
X_1639_ _1323_ net425 net195 VPWR VGND sg13g2_nand2b_1
Xfanout402 net404 net402 VPWR VGND sg13g2_buf_8
XFILLER_46_308 VPWR VGND sg13g2_decap_4
XFILLER_39_371 VPWR VGND sg13g2_decap_8
XFILLER_27_500 VPWR VGND sg13g2_decap_8
XFILLER_42_503 VPWR VGND sg13g2_decap_4
XFILLER_15_706 VPWR VGND sg13g2_fill_1
XFILLER_15_728 VPWR VGND sg13g2_decap_8
XFILLER_42_525 VPWR VGND sg13g2_decap_8
XFILLER_14_227 VPWR VGND sg13g2_decap_8
XFILLER_27_599 VPWR VGND sg13g2_decap_4
XFILLER_14_249 VPWR VGND sg13g2_decap_8
XFILLER_10_422 VPWR VGND sg13g2_decap_8
XFILLER_7_905 VPWR VGND sg13g2_decap_8
XFILLER_11_967 VPWR VGND sg13g2_decap_8
XFILLER_22_293 VPWR VGND sg13g2_decap_8
XFILLER_6_426 VPWR VGND sg13g2_fill_1
XFILLER_10_477 VPWR VGND sg13g2_decap_8
XFILLER_13_85 VPWR VGND sg13g2_decap_8
XFILLER_2_665 VPWR VGND sg13g2_decap_8
XFILLER_49_135 VPWR VGND sg13g2_fill_2
XFILLER_46_820 VPWR VGND sg13g2_decap_8
XFILLER_38_71 VPWR VGND sg13g2_decap_8
XFILLER_46_897 VPWR VGND sg13g2_decap_8
X_1990_ _0466_ _0262_ _0465_ VPWR VGND sg13g2_xnor2_1
XFILLER_33_547 VPWR VGND sg13g2_fill_1
X_2852__92 VPWR VGND net92 sg13g2_tiehi
XFILLER_20_219 VPWR VGND sg13g2_decap_8
XFILLER_9_264 VPWR VGND sg13g2_fill_2
Xclkload12 VPWR clkload12/Y clknet_4_14_0_clk VGND sg13g2_inv_1
X_2611_ net358 net334 _0951_ VPWR VGND sg13g2_xor2_1
X_2542_ _0867_ VPWR _0917_ VGND _0889_ _0916_ sg13g2_o21ai_1
XFILLER_6_993 VPWR VGND sg13g2_decap_8
XFILLER_5_492 VPWR VGND sg13g2_decap_8
X_2473_ _0764_ _0870_ _0871_ VPWR VGND sg13g2_nor2_2
XFILLER_29_809 VPWR VGND sg13g2_fill_1
XFILLER_36_363 VPWR VGND sg13g2_fill_2
XFILLER_36_385 VPWR VGND sg13g2_decap_8
XFILLER_36_396 VPWR VGND sg13g2_fill_1
XFILLER_20_764 VPWR VGND sg13g2_fill_1
Xclkload6 VPWR clkload6/Y clknet_4_7_0_clk VGND sg13g2_inv_1
XFILLER_30_1000 VPWR VGND sg13g2_decap_8
X_2809_ _1147_ net347 net341 VPWR VGND sg13g2_nand2_1
XFILLER_8_1012 VPWR VGND sg13g2_decap_8
Xfanout287 net288 net287 VPWR VGND sg13g2_buf_8
Xfanout298 _0923_ net298 VPWR VGND sg13g2_buf_8
XFILLER_46_127 VPWR VGND sg13g2_fill_2
XFILLER_43_801 VPWR VGND sg13g2_decap_8
XFILLER_28_853 VPWR VGND sg13g2_decap_8
XFILLER_15_525 VPWR VGND sg13g2_decap_8
XFILLER_43_878 VPWR VGND sg13g2_decap_8
XFILLER_15_569 VPWR VGND sg13g2_decap_8
XFILLER_42_366 VPWR VGND sg13g2_fill_2
XFILLER_30_517 VPWR VGND sg13g2_decap_8
XFILLER_24_62 VPWR VGND sg13g2_decap_8
XFILLER_7_702 VPWR VGND sg13g2_decap_8
XFILLER_11_764 VPWR VGND sg13g2_decap_8
XFILLER_6_223 VPWR VGND sg13g2_decap_8
XFILLER_7_779 VPWR VGND sg13g2_decap_8
XFILLER_6_289 VPWR VGND sg13g2_decap_4
XFILLER_3_963 VPWR VGND sg13g2_decap_8
XFILLER_2_462 VPWR VGND sg13g2_decap_8
XFILLER_27_7 VPWR VGND sg13g2_decap_8
XFILLER_37_127 VPWR VGND sg13g2_decap_4
XFILLER_19_842 VPWR VGND sg13g2_decap_8
XFILLER_46_694 VPWR VGND sg13g2_fill_2
XFILLER_46_672 VPWR VGND sg13g2_decap_8
XFILLER_34_856 VPWR VGND sg13g2_decap_8
XFILLER_21_528 VPWR VGND sg13g2_decap_8
X_2908__162 VPWR VGND net162 sg13g2_tiehi
X_1973_ VGND VPWR _0751_ net278 _0450_ net285 sg13g2_a21oi_1
XFILLER_33_399 VPWR VGND sg13g2_decap_8
XFILLER_14_1006 VPWR VGND sg13g2_decap_8
XFILLER_6_790 VPWR VGND sg13g2_decap_8
X_2525_ falutop.i2c_inst.data_in\[14\] falutop.data_in\[14\] net319 _0042_ VPWR VGND
+ sg13g2_mux2_1
X_2456_ falutop.i2c_inst.data_in\[18\] net321 _0857_ VPWR VGND sg13g2_nor2_1
Xhold29 _0011_ VPWR VGND net203 sg13g2_dlygate4sd3_1
Xhold18 falutop.div_inst.quo\[5\] VPWR VGND net192 sg13g2_dlygate4sd3_1
XFILLER_29_18 VPWR VGND sg13g2_decap_8
X_2387_ VGND VPWR net386 falutop.div_inst.a\[7\] _0799_ _0798_ sg13g2_a21oi_1
XFILLER_28_105 VPWR VGND sg13g2_decap_8
XFILLER_37_672 VPWR VGND sg13g2_decap_8
XFILLER_24_344 VPWR VGND sg13g2_fill_1
XFILLER_40_826 VPWR VGND sg13g2_decap_8
XFILLER_25_889 VPWR VGND sg13g2_decap_8
XFILLER_4_727 VPWR VGND sg13g2_decap_8
XFILLER_3_248 VPWR VGND sg13g2_decap_8
XFILLER_0_911 VPWR VGND sg13g2_decap_8
XFILLER_0_988 VPWR VGND sg13g2_decap_8
XFILLER_48_948 VPWR VGND sg13g2_decap_8
XFILLER_47_469 VPWR VGND sg13g2_decap_8
XFILLER_35_609 VPWR VGND sg13g2_decap_8
XFILLER_15_311 VPWR VGND sg13g2_decap_8
XFILLER_16_834 VPWR VGND sg13g2_decap_8
XFILLER_28_672 VPWR VGND sg13g2_decap_8
XFILLER_37_1006 VPWR VGND sg13g2_decap_8
XFILLER_15_388 VPWR VGND sg13g2_decap_8
XFILLER_30_347 VPWR VGND sg13g2_decap_8
XFILLER_30_369 VPWR VGND sg13g2_decap_8
XFILLER_11_594 VPWR VGND sg13g2_fill_2
XFILLER_7_576 VPWR VGND sg13g2_decap_8
X_2310_ net408 VPWR _0730_ VGND falutop.i2c_inst.data_in\[18\] _0729_ sg13g2_o21ai_1
XFILLER_3_760 VPWR VGND sg13g2_decap_8
XFILLER_2_270 VPWR VGND sg13g2_decap_4
X_2241_ net204 net301 _0681_ VPWR VGND sg13g2_nor2_1
XFILLER_38_403 VPWR VGND sg13g2_decap_4
XFILLER_25_4 VPWR VGND sg13g2_decap_8
XFILLER_39_959 VPWR VGND sg13g2_decap_8
X_2172_ falutop.data_in\[4\] net298 _0637_ VPWR VGND sg13g2_nor2_1
XFILLER_19_661 VPWR VGND sg13g2_fill_1
XFILLER_25_108 VPWR VGND sg13g2_decap_8
XFILLER_33_130 VPWR VGND sg13g2_decap_8
XFILLER_33_163 VPWR VGND sg13g2_decap_8
XFILLER_34_697 VPWR VGND sg13g2_decap_8
X_1956_ _0433_ _0423_ _0431_ VPWR VGND sg13g2_xnor2_1
XFILLER_21_347 VPWR VGND sg13g2_fill_1
XFILLER_30_881 VPWR VGND sg13g2_decap_8
X_1887_ net407 VPWR _0366_ VGND net255 net304 sg13g2_o21ai_1
XFILLER_0_207 VPWR VGND sg13g2_fill_2
X_2508_ net405 net316 _0900_ VPWR VGND sg13g2_and2_1
X_2895__32 VPWR VGND net32 sg13g2_tiehi
X_2439_ _0845_ net283 _0844_ VPWR VGND sg13g2_nand2_1
XFILLER_29_414 VPWR VGND sg13g2_decap_4
XFILLER_29_436 VPWR VGND sg13g2_decap_8
XFILLER_38_981 VPWR VGND sg13g2_decap_8
XFILLER_16_108 VPWR VGND sg13g2_fill_1
XFILLER_25_620 VPWR VGND sg13g2_decap_4
XFILLER_24_141 VPWR VGND sg13g2_decap_8
XFILLER_24_196 VPWR VGND sg13g2_fill_2
XFILLER_8_318 VPWR VGND sg13g2_fill_1
XFILLER_9_819 VPWR VGND sg13g2_decap_8
XFILLER_4_524 VPWR VGND sg13g2_decap_8
XFILLER_48_745 VPWR VGND sg13g2_decap_8
XFILLER_47_222 VPWR VGND sg13g2_decap_8
XFILLER_0_785 VPWR VGND sg13g2_decap_8
XFILLER_47_288 VPWR VGND sg13g2_decap_8
XFILLER_35_428 VPWR VGND sg13g2_decap_8
XFILLER_44_984 VPWR VGND sg13g2_decap_8
XFILLER_15_152 VPWR VGND sg13g2_decap_4
XFILLER_16_686 VPWR VGND sg13g2_fill_1
X_1810_ VGND VPWR _0290_ _0289_ _0288_ sg13g2_or2_1
XFILLER_8_830 VPWR VGND sg13g2_decap_8
XFILLER_12_870 VPWR VGND sg13g2_decap_8
X_2790_ VGND VPWR _0976_ _1072_ _1129_ _1128_ sg13g2_a21oi_1
XFILLER_11_1009 VPWR VGND sg13g2_decap_8
X_1741_ _0220_ _0191_ _0222_ VPWR VGND sg13g2_xor2_1
X_2975__119 VPWR VGND net119 sg13g2_tiehi
X_1672_ _0151_ _0152_ _0153_ _0154_ VPWR VGND sg13g2_or3_1
X_2224_ VGND VPWR net301 _0668_ _0121_ _0666_ sg13g2_a21oi_1
XFILLER_39_767 VPWR VGND sg13g2_fill_1
XFILLER_39_756 VPWR VGND sg13g2_decap_8
XFILLER_38_255 VPWR VGND sg13g2_decap_8
X_2155_ falutop.data_in\[12\] falutop.data_in\[13\] _0625_ _0626_ VPWR VGND sg13g2_or3_1
XFILLER_38_277 VPWR VGND sg13g2_decap_8
X_2086_ _0560_ _0546_ _0558_ VPWR VGND sg13g2_xnor2_1
XFILLER_35_962 VPWR VGND sg13g2_decap_8
XFILLER_21_111 VPWR VGND sg13g2_decap_8
XFILLER_22_612 VPWR VGND sg13g2_fill_1
XFILLER_22_623 VPWR VGND sg13g2_decap_8
XFILLER_42_29 VPWR VGND sg13g2_fill_2
X_2988_ net137 VGND VPWR _0145_ falutop.i2c_inst.data_in\[17\] net397 sg13g2_dfrbpq_1
X_2947__69 VPWR VGND net69 sg13g2_tiehi
X_1939_ VGND VPWR _0416_ _0415_ _0370_ sg13g2_or2_1
XFILLER_45_737 VPWR VGND sg13g2_decap_8
XFILLER_29_255 VPWR VGND sg13g2_decap_8
XFILLER_16_30 VPWR VGND sg13g2_decap_8
XFILLER_16_41 VPWR VGND sg13g2_fill_1
XFILLER_26_973 VPWR VGND sg13g2_decap_8
XFILLER_41_954 VPWR VGND sg13g2_decap_8
XFILLER_40_431 VPWR VGND sg13g2_decap_8
XFILLER_9_616 VPWR VGND sg13g2_decap_8
XFILLER_12_122 VPWR VGND sg13g2_decap_8
XFILLER_13_689 VPWR VGND sg13g2_decap_8
XFILLER_8_137 VPWR VGND sg13g2_decap_8
XFILLER_32_51 VPWR VGND sg13g2_fill_1
XFILLER_5_800 VPWR VGND sg13g2_decap_8
XFILLER_5_877 VPWR VGND sg13g2_decap_8
XFILLER_4_376 VPWR VGND sg13g2_fill_2
XFILLER_4_365 VPWR VGND sg13g2_decap_8
XFILLER_4_398 VPWR VGND sg13g2_decap_8
XFILLER_0_582 VPWR VGND sg13g2_decap_8
XFILLER_36_737 VPWR VGND sg13g2_decap_4
XFILLER_17_940 VPWR VGND sg13g2_decap_8
XFILLER_44_781 VPWR VGND sg13g2_decap_8
X_2911_ net156 VGND VPWR _0068_ falutop.div_inst.val\[5\] clknet_4_7_0_clk sg13g2_dfrbpq_1
XFILLER_32_932 VPWR VGND sg13g2_decap_8
XFILLER_43_280 VPWR VGND sg13g2_decap_8
X_2842_ _1180_ _1056_ _1179_ VPWR VGND sg13g2_nand2_1
XFILLER_31_475 VPWR VGND sg13g2_decap_8
X_2773_ _0974_ _1000_ _1112_ VPWR VGND sg13g2_nor2_1
X_1724_ _0205_ falutop.alu_data_in\[10\] net363 VPWR VGND sg13g2_nand2_1
Xhold126 falutop.alu_data_in\[13\] VPWR VGND net433 sg13g2_dlygate4sd3_1
XFILLER_7_170 VPWR VGND sg13g2_decap_8
Xhold104 falutop.div_inst.rem\[5\] VPWR VGND net411 sg13g2_dlygate4sd3_1
Xhold115 falutop.alu_data_in\[4\] VPWR VGND net422 sg13g2_dlygate4sd3_1
X_1655_ _1277_ VPWR _1338_ VGND _1266_ _1278_ sg13g2_o21ai_1
X_1586_ VGND VPWR _1270_ _1269_ _1268_ sg13g2_or2_1
X_2207_ VGND VPWR net302 _0656_ _0116_ _0654_ sg13g2_a21oi_1
XFILLER_27_715 VPWR VGND sg13g2_decap_8
X_2138_ net409 VPWR _0611_ VGND net261 net304 sg13g2_o21ai_1
X_2069_ VGND VPWR _0543_ _0542_ net327 sg13g2_or2_1
XFILLER_42_729 VPWR VGND sg13g2_fill_1
XFILLER_23_932 VPWR VGND sg13g2_decap_8
XFILLER_35_770 VPWR VGND sg13g2_fill_2
XFILLER_6_608 VPWR VGND sg13g2_decap_8
XFILLER_10_659 VPWR VGND sg13g2_decap_8
XFILLER_5_107 VPWR VGND sg13g2_decap_8
XFILLER_2_847 VPWR VGND sg13g2_decap_8
XFILLER_49_306 VPWR VGND sg13g2_fill_1
XFILLER_1_357 VPWR VGND sg13g2_decap_8
XFILLER_1_335 VPWR VGND sg13g2_fill_1
XFILLER_49_339 VPWR VGND sg13g2_decap_8
XFILLER_45_512 VPWR VGND sg13g2_fill_1
XFILLER_40_1024 VPWR VGND sg13g2_decap_4
XFILLER_32_217 VPWR VGND sg13g2_decap_8
XFILLER_32_239 VPWR VGND sg13g2_decap_8
XFILLER_14_943 VPWR VGND sg13g2_decap_8
Xheichips25_template_7 VPWR VGND uio_oe[2] sg13g2_tielo
XFILLER_5_674 VPWR VGND sg13g2_decap_8
XFILLER_4_11 VPWR VGND sg13g2_decap_8
XFILLER_4_66 VPWR VGND sg13g2_decap_4
XFILLER_49_895 VPWR VGND sg13g2_decap_8
XFILLER_36_512 VPWR VGND sg13g2_decap_4
XFILLER_17_792 VPWR VGND sg13g2_decap_8
XFILLER_23_217 VPWR VGND sg13g2_decap_8
X_2870__60 VPWR VGND net60 sg13g2_tiehi
XFILLER_31_250 VPWR VGND sg13g2_decap_8
X_2825_ _1163_ net347 net375 VPWR VGND sg13g2_nand2_1
XFILLER_20_957 VPWR VGND sg13g2_decap_8
XFILLER_31_294 VPWR VGND sg13g2_decap_8
XFILLER_9_980 VPWR VGND sg13g2_decap_8
X_2756_ VGND VPWR _1095_ _1094_ _1017_ sg13g2_or2_1
X_1707_ VPWR VGND net316 net307 _0188_ net290 _0189_ _0185_ sg13g2_a221oi_1
X_2687_ VGND VPWR _1026_ _1027_ net324 net335 sg13g2_a21oi_2
X_1638_ _1320_ _1321_ net195 _1322_ VPWR VGND sg13g2_nand3_1
X_2918__142 VPWR VGND net142 sg13g2_tiehi
Xfanout403 net404 net403 VPWR VGND sg13g2_buf_8
XFILLER_48_28 VPWR VGND sg13g2_decap_8
X_1569_ _1251_ _1253_ _1254_ VPWR VGND sg13g2_nor2_1
XFILLER_39_350 VPWR VGND sg13g2_decap_8
XFILLER_27_534 VPWR VGND sg13g2_decap_8
XFILLER_27_578 VPWR VGND sg13g2_decap_8
X_2964__151 VPWR VGND net151 sg13g2_tiehi
XFILLER_10_401 VPWR VGND sg13g2_decap_8
XFILLER_11_946 VPWR VGND sg13g2_decap_8
XFILLER_13_31 VPWR VGND sg13g2_fill_2
XFILLER_22_272 VPWR VGND sg13g2_decap_8
XFILLER_23_795 VPWR VGND sg13g2_fill_2
XFILLER_13_64 VPWR VGND sg13g2_decap_8
XFILLER_2_644 VPWR VGND sg13g2_decap_8
XFILLER_49_114 VPWR VGND sg13g2_decap_8
XFILLER_1_198 VPWR VGND sg13g2_decap_4
XFILLER_18_523 VPWR VGND sg13g2_fill_1
XFILLER_46_876 VPWR VGND sg13g2_decap_8
XFILLER_18_578 VPWR VGND sg13g2_fill_2
XFILLER_45_386 VPWR VGND sg13g2_decap_8
XFILLER_33_515 VPWR VGND sg13g2_decap_8
XFILLER_13_261 VPWR VGND sg13g2_decap_8
XFILLER_14_762 VPWR VGND sg13g2_decap_8
XFILLER_9_243 VPWR VGND sg13g2_decap_8
XFILLER_9_210 VPWR VGND sg13g2_fill_1
XFILLER_13_272 VPWR VGND sg13g2_fill_2
Xclkload13 VPWR clkload13/Y clknet_4_15_0_clk VGND sg13g2_inv_1
X_2610_ _0950_ _0754_ net358 VPWR VGND sg13g2_nand2_1
XFILLER_9_298 VPWR VGND sg13g2_decap_8
XFILLER_6_972 VPWR VGND sg13g2_decap_8
X_2541_ _0915_ VPWR _0916_ VGND _0874_ _0912_ sg13g2_o21ai_1
XFILLER_47_1008 VPWR VGND sg13g2_decap_8
X_2472_ _0870_ _0869_ VPWR VGND sg13g2_inv_2
XFILLER_5_471 VPWR VGND sg13g2_decap_8
XFILLER_49_692 VPWR VGND sg13g2_decap_8
XFILLER_36_331 VPWR VGND sg13g2_fill_2
XFILLER_36_342 VPWR VGND sg13g2_decap_8
XFILLER_37_887 VPWR VGND sg13g2_decap_8
XFILLER_24_515 VPWR VGND sg13g2_fill_2
XFILLER_20_721 VPWR VGND sg13g2_decap_8
XFILLER_32_581 VPWR VGND sg13g2_fill_2
Xclkload7 VPWR clkload7/Y clknet_4_9_0_clk VGND sg13g2_inv_1
X_2808_ net348 net371 _0991_ _1146_ VPWR VGND sg13g2_mux2_1
XFILLER_4_909 VPWR VGND sg13g2_decap_8
X_2739_ net405 VPWR _1079_ VGND net274 net305 sg13g2_o21ai_1
XFILLER_46_106 VPWR VGND sg13g2_decap_8
Xfanout288 _0776_ net288 VPWR VGND sg13g2_buf_8
Xfanout299 net300 net299 VPWR VGND sg13g2_buf_8
XFILLER_19_309 VPWR VGND sg13g2_fill_2
XFILLER_15_515 VPWR VGND sg13g2_decap_4
XFILLER_43_857 VPWR VGND sg13g2_decap_8
XFILLER_42_345 VPWR VGND sg13g2_decap_8
XFILLER_11_743 VPWR VGND sg13g2_decap_8
XFILLER_23_592 VPWR VGND sg13g2_decap_8
XFILLER_10_286 VPWR VGND sg13g2_fill_1
XFILLER_7_758 VPWR VGND sg13g2_decap_8
XFILLER_40_84 VPWR VGND sg13g2_decap_8
XFILLER_3_942 VPWR VGND sg13g2_decap_8
XFILLER_2_441 VPWR VGND sg13g2_decap_8
XFILLER_49_93 VPWR VGND sg13g2_decap_8
XFILLER_37_106 VPWR VGND sg13g2_decap_8
XFILLER_1_56 VPWR VGND sg13g2_decap_4
XFILLER_46_651 VPWR VGND sg13g2_decap_8
XFILLER_34_802 VPWR VGND sg13g2_fill_2
XFILLER_19_898 VPWR VGND sg13g2_decap_8
XFILLER_33_312 VPWR VGND sg13g2_fill_1
XFILLER_34_835 VPWR VGND sg13g2_decap_8
XFILLER_33_367 VPWR VGND sg13g2_decap_8
X_1972_ _0448_ VPWR _0449_ VGND _0445_ _0447_ sg13g2_o21ai_1
XFILLER_14_570 VPWR VGND sg13g2_fill_1
X_2524_ falutop.i2c_inst.data_in\[13\] falutop.data_in\[13\] net320 _0041_ VPWR VGND
+ sg13g2_mux2_1
XFILLER_46_0 VPWR VGND sg13g2_decap_8
X_2455_ falutop.i2c_inst.data_in\[17\] falutop.i2c_inst.op\[1\] net321 _0017_ VPWR
+ VGND sg13g2_mux2_1
X_2386_ net386 net180 _0798_ VPWR VGND sg13g2_nor2b_1
Xhold19 falutop.div_inst.quo\[2\] VPWR VGND net193 sg13g2_dlygate4sd3_1
XFILLER_29_607 VPWR VGND sg13g2_decap_8
XFILLER_24_378 VPWR VGND sg13g2_decap_8
XFILLER_33_890 VPWR VGND sg13g2_decap_8
XFILLER_20_551 VPWR VGND sg13g2_fill_2
XFILLER_20_573 VPWR VGND sg13g2_decap_4
XFILLER_4_706 VPWR VGND sg13g2_decap_8
XFILLER_3_227 VPWR VGND sg13g2_decap_8
XFILLER_10_98 VPWR VGND sg13g2_fill_1
XFILLER_48_927 VPWR VGND sg13g2_decap_8
XFILLER_0_967 VPWR VGND sg13g2_decap_8
XFILLER_47_448 VPWR VGND sg13g2_decap_8
XFILLER_19_139 VPWR VGND sg13g2_fill_1
XFILLER_42_120 VPWR VGND sg13g2_decap_8
XFILLER_27_194 VPWR VGND sg13g2_fill_2
XFILLER_42_153 VPWR VGND sg13g2_fill_2
XFILLER_42_142 VPWR VGND sg13g2_fill_1
XFILLER_15_367 VPWR VGND sg13g2_decap_8
XFILLER_31_805 VPWR VGND sg13g2_decap_8
XFILLER_35_62 VPWR VGND sg13g2_decap_8
XFILLER_42_197 VPWR VGND sg13g2_decap_8
XFILLER_30_337 VPWR VGND sg13g2_fill_1
XFILLER_31_849 VPWR VGND sg13g2_decap_8
XFILLER_7_555 VPWR VGND sg13g2_decap_8
X_2240_ VGND VPWR net301 _0680_ _0125_ _0679_ sg13g2_a21oi_1
XFILLER_39_938 VPWR VGND sg13g2_decap_8
X_2171_ VGND VPWR _0763_ net294 _0100_ _0636_ sg13g2_a21oi_1
XFILLER_18_194 VPWR VGND sg13g2_decap_8
XFILLER_33_153 VPWR VGND sg13g2_decap_4
XFILLER_34_676 VPWR VGND sg13g2_decap_8
XFILLER_33_186 VPWR VGND sg13g2_fill_1
X_1955_ _0423_ _0431_ _0432_ VPWR VGND sg13g2_nor2b_1
XFILLER_21_359 VPWR VGND sg13g2_decap_8
XFILLER_30_860 VPWR VGND sg13g2_decap_8
X_1886_ VPWR VGND _0364_ net307 net290 falutop.div_inst.rem\[0\] _0365_ net316 sg13g2_a221oi_1
X_2507_ _0899_ net316 net195 VPWR VGND sg13g2_nand2b_1
X_2438_ _0844_ _0817_ _0818_ VPWR VGND sg13g2_xnor2_1
X_2369_ VGND VPWR _0776_ _0784_ _0002_ _0785_ sg13g2_a21oi_1
XFILLER_45_919 VPWR VGND sg13g2_decap_8
XFILLER_38_960 VPWR VGND sg13g2_decap_8
XFILLER_44_407 VPWR VGND sg13g2_fill_1
XFILLER_24_120 VPWR VGND sg13g2_fill_2
XFILLER_25_665 VPWR VGND sg13g2_fill_1
XFILLER_12_304 VPWR VGND sg13g2_decap_8
XFILLER_13_849 VPWR VGND sg13g2_decap_8
XFILLER_40_646 VPWR VGND sg13g2_decap_4
XFILLER_20_381 VPWR VGND sg13g2_decap_8
XFILLER_20_392 VPWR VGND sg13g2_fill_1
XFILLER_21_31 VPWR VGND sg13g2_fill_2
XFILLER_4_503 VPWR VGND sg13g2_decap_8
XFILLER_21_97 VPWR VGND sg13g2_decap_8
XFILLER_43_1011 VPWR VGND sg13g2_decap_8
XFILLER_0_764 VPWR VGND sg13g2_decap_8
XFILLER_48_724 VPWR VGND sg13g2_decap_8
XFILLER_47_201 VPWR VGND sg13g2_decap_4
X_2886__44 VPWR VGND net44 sg13g2_tiehi
XFILLER_47_267 VPWR VGND sg13g2_decap_8
XFILLER_46_61 VPWR VGND sg13g2_decap_8
XFILLER_29_993 VPWR VGND sg13g2_decap_8
XFILLER_35_418 VPWR VGND sg13g2_decap_4
XFILLER_44_963 VPWR VGND sg13g2_decap_8
XFILLER_15_131 VPWR VGND sg13g2_decap_8
XFILLER_16_654 VPWR VGND sg13g2_decap_8
XFILLER_30_134 VPWR VGND sg13g2_decap_8
XFILLER_30_145 VPWR VGND sg13g2_fill_2
XFILLER_31_668 VPWR VGND sg13g2_decap_8
X_1740_ _0191_ _0220_ _0221_ VPWR VGND sg13g2_and2_1
XFILLER_8_886 VPWR VGND sg13g2_decap_8
X_1671_ _0153_ net361 net355 net363 net349 VPWR VGND sg13g2_a22oi_1
XFILLER_39_735 VPWR VGND sg13g2_fill_2
XFILLER_39_724 VPWR VGND sg13g2_decap_8
X_2223_ _0667_ falutop.data_in\[9\] _0668_ VPWR VGND sg13g2_xor2_1
XFILLER_39_779 VPWR VGND sg13g2_decap_8
XFILLER_38_245 VPWR VGND sg13g2_decap_4
X_2154_ _0625_ _0624_ falutop.data_in\[11\] VPWR VGND sg13g2_nand2b_1
X_2892__36 VPWR VGND net36 sg13g2_tiehi
X_2085_ _0546_ _0558_ _0559_ VPWR VGND sg13g2_nor2_1
XFILLER_19_481 VPWR VGND sg13g2_decap_8
XFILLER_35_941 VPWR VGND sg13g2_decap_8
XFILLER_22_602 VPWR VGND sg13g2_fill_1
XFILLER_34_495 VPWR VGND sg13g2_fill_2
X_2987_ net113 VGND VPWR _0144_ falutop.i2c_inst.data_in\[16\] net398 sg13g2_dfrbpq_1
XFILLER_22_679 VPWR VGND sg13g2_decap_8
XFILLER_30_690 VPWR VGND sg13g2_fill_2
X_1938_ _0415_ _0262_ _0378_ _0958_ _0952_ VPWR VGND sg13g2_a22oi_1
X_1869_ _0348_ _0333_ _0347_ VPWR VGND sg13g2_nand2b_1
XFILLER_1_539 VPWR VGND sg13g2_decap_8
XFILLER_29_234 VPWR VGND sg13g2_decap_8
XFILLER_18_919 VPWR VGND sg13g2_decap_8
X_2883__47 VPWR VGND net47 sg13g2_tiehi
XFILLER_26_952 VPWR VGND sg13g2_decap_8
X_2928__122 VPWR VGND net122 sg13g2_tiehi
XFILLER_41_933 VPWR VGND sg13g2_decap_8
XFILLER_25_495 VPWR VGND sg13g2_decap_8
XFILLER_13_668 VPWR VGND sg13g2_decap_8
XFILLER_16_97 VPWR VGND sg13g2_decap_8
XFILLER_40_487 VPWR VGND sg13g2_fill_2
XFILLER_8_116 VPWR VGND sg13g2_decap_8
XFILLER_8_149 VPWR VGND sg13g2_decap_8
XFILLER_5_856 VPWR VGND sg13g2_decap_8
XFILLER_4_388 VPWR VGND sg13g2_fill_1
XFILLER_0_561 VPWR VGND sg13g2_decap_8
XFILLER_36_727 VPWR VGND sg13g2_decap_4
XFILLER_44_760 VPWR VGND sg13g2_decap_8
XFILLER_16_440 VPWR VGND sg13g2_decap_8
XFILLER_35_259 VPWR VGND sg13g2_decap_8
XFILLER_17_996 VPWR VGND sg13g2_decap_8
X_2910_ net158 VGND VPWR _0067_ falutop.div_inst.val\[4\] clknet_4_7_0_clk sg13g2_dfrbpq_1
XFILLER_32_911 VPWR VGND sg13g2_decap_8
X_2841_ _1179_ _1025_ _1058_ VPWR VGND sg13g2_nand2_1
XFILLER_32_988 VPWR VGND sg13g2_decap_8
X_2772_ net352 net351 _1062_ _1110_ _1111_ VPWR VGND sg13g2_nor4_1
XFILLER_8_683 VPWR VGND sg13g2_decap_8
X_1723_ _0204_ net332 net376 VPWR VGND sg13g2_nand2_1
Xhold116 falutop.alu_data_in\[5\] VPWR VGND net423 sg13g2_dlygate4sd3_1
Xhold105 falutop.div_inst.rem\[7\] VPWR VGND net412 sg13g2_dlygate4sd3_1
Xhold127 falutop.alu_data_in\[6\] VPWR VGND net434 sg13g2_dlygate4sd3_1
X_1654_ _1335_ _1326_ _1337_ VPWR VGND sg13g2_xor2_1
X_1585_ VGND VPWR net349 net330 _1269_ net363 sg13g2_a21oi_1
XFILLER_39_532 VPWR VGND sg13g2_fill_1
X_2206_ _0656_ falutop.data_in\[3\] _0655_ VPWR VGND sg13g2_xnor2_1
XFILLER_39_565 VPWR VGND sg13g2_decap_8
XFILLER_2_1008 VPWR VGND sg13g2_decap_8
X_2137_ VGND VPWR net317 _0609_ _0610_ net307 sg13g2_a21oi_1
XFILLER_42_708 VPWR VGND sg13g2_fill_1
X_2068_ VGND VPWR _1329_ _0542_ _0508_ _0262_ sg13g2_a21oi_2
XFILLER_26_259 VPWR VGND sg13g2_decap_8
XFILLER_23_911 VPWR VGND sg13g2_decap_8
XFILLER_23_988 VPWR VGND sg13g2_decap_8
XFILLER_10_638 VPWR VGND sg13g2_decap_8
XFILLER_2_826 VPWR VGND sg13g2_decap_8
XFILLER_1_303 VPWR VGND sg13g2_decap_4
XFILLER_49_318 VPWR VGND sg13g2_decap_8
XFILLER_40_1003 VPWR VGND sg13g2_decap_8
XFILLER_27_41 VPWR VGND sg13g2_decap_8
XFILLER_17_259 VPWR VGND sg13g2_fill_2
XFILLER_14_922 VPWR VGND sg13g2_decap_8
XFILLER_41_752 VPWR VGND sg13g2_fill_2
XFILLER_25_281 VPWR VGND sg13g2_decap_8
XFILLER_25_292 VPWR VGND sg13g2_fill_2
XFILLER_14_999 VPWR VGND sg13g2_decap_8
XFILLER_43_84 VPWR VGND sg13g2_fill_2
XFILLER_40_295 VPWR VGND sg13g2_decap_8
XFILLER_9_469 VPWR VGND sg13g2_decap_8
Xheichips25_template_8 VPWR VGND uio_oe[3] sg13g2_tielo
XFILLER_5_653 VPWR VGND sg13g2_decap_8
XFILLER_4_185 VPWR VGND sg13g2_fill_2
XFILLER_49_874 VPWR VGND sg13g2_decap_8
XFILLER_36_568 VPWR VGND sg13g2_decap_8
XFILLER_36_579 VPWR VGND sg13g2_fill_1
X_2824_ _1160_ _1105_ _1162_ VPWR VGND sg13g2_xor2_1
XFILLER_20_936 VPWR VGND sg13g2_decap_8
XFILLER_8_480 VPWR VGND sg13g2_decap_8
X_2755_ VGND VPWR net325 net284 _1094_ _1093_ sg13g2_a21oi_1
X_1706_ _0186_ _0187_ _0188_ VPWR VGND sg13g2_and2_1
X_2686_ _1026_ net323 _1025_ VPWR VGND sg13g2_nand2_1
X_1637_ _1259_ net318 falutop.div_inst.val\[4\] _1321_ VPWR VGND sg13g2_a21o_1
Xfanout404 rst_n net404 VPWR VGND sg13g2_buf_8
X_1568_ VGND VPWR _1249_ _1250_ _1253_ _1237_ sg13g2_a21oi_1
X_2940__87 VPWR VGND net87 sg13g2_tiehi
X_1499_ VGND VPWR net335 net328 _1185_ _1017_ sg13g2_a21oi_1
XFILLER_27_513 VPWR VGND sg13g2_decap_8
XFILLER_14_207 VPWR VGND sg13g2_decap_8
XFILLER_23_741 VPWR VGND sg13g2_fill_1
XFILLER_11_925 VPWR VGND sg13g2_decap_8
XFILLER_10_446 VPWR VGND sg13g2_decap_8
XFILLER_13_43 VPWR VGND sg13g2_decap_8
XFILLER_2_623 VPWR VGND sg13g2_decap_8
XFILLER_1_166 VPWR VGND sg13g2_decap_4
XFILLER_49_137 VPWR VGND sg13g2_fill_1
XFILLER_18_502 VPWR VGND sg13g2_decap_8
XFILLER_46_855 VPWR VGND sg13g2_decap_8
XFILLER_45_365 VPWR VGND sg13g2_decap_8
XFILLER_14_730 VPWR VGND sg13g2_decap_8
XFILLER_33_538 VPWR VGND sg13g2_decap_8
XFILLER_41_560 VPWR VGND sg13g2_decap_4
XFILLER_41_582 VPWR VGND sg13g2_decap_8
XFILLER_14_796 VPWR VGND sg13g2_decap_8
XFILLER_9_277 VPWR VGND sg13g2_decap_8
XFILLER_6_951 VPWR VGND sg13g2_decap_8
XFILLER_5_450 VPWR VGND sg13g2_decap_8
X_2540_ _0913_ _0914_ _0874_ _0915_ VPWR VGND sg13g2_nand3_1
X_2471_ _0867_ _0868_ _0869_ VPWR VGND sg13g2_nor2_2
XFILLER_49_671 VPWR VGND sg13g2_decap_8
XFILLER_37_811 VPWR VGND sg13g2_decap_8
XFILLER_37_866 VPWR VGND sg13g2_decap_8
XFILLER_24_505 VPWR VGND sg13g2_decap_4
XFILLER_36_365 VPWR VGND sg13g2_fill_1
X_2844__101 VPWR VGND net101 sg13g2_tiehi
XFILLER_32_560 VPWR VGND sg13g2_decap_8
XFILLER_32_571 VPWR VGND sg13g2_fill_1
Xclkload8 VPWR clkload8/Y clknet_4_10_0_clk VGND sg13g2_inv_1
XFILLER_20_755 VPWR VGND sg13g2_decap_8
X_2807_ _1014_ VPWR _1145_ VGND _1083_ _1087_ sg13g2_o21ai_1
XFILLER_20_788 VPWR VGND sg13g2_decap_8
X_2738_ _1077_ VPWR _1078_ VGND falutop.div_inst.val\[0\] net315 sg13g2_o21ai_1
X_2669_ _0966_ _1008_ _1009_ VPWR VGND sg13g2_and2_1
Xfanout289 _0775_ net289 VPWR VGND sg13g2_buf_8
Xfanout278 net279 net278 VPWR VGND sg13g2_buf_8
XFILLER_28_811 VPWR VGND sg13g2_decap_8
XFILLER_27_343 VPWR VGND sg13g2_decap_8
XFILLER_43_836 VPWR VGND sg13g2_decap_8
XFILLER_28_888 VPWR VGND sg13g2_decap_8
XFILLER_42_324 VPWR VGND sg13g2_decap_8
XFILLER_42_379 VPWR VGND sg13g2_decap_8
XFILLER_11_722 VPWR VGND sg13g2_decap_8
XFILLER_10_232 VPWR VGND sg13g2_decap_8
XFILLER_7_737 VPWR VGND sg13g2_decap_8
XFILLER_11_799 VPWR VGND sg13g2_decap_8
XFILLER_40_63 VPWR VGND sg13g2_decap_8
XFILLER_6_258 VPWR VGND sg13g2_decap_4
XFILLER_3_921 VPWR VGND sg13g2_decap_8
XFILLER_2_420 VPWR VGND sg13g2_decap_8
XFILLER_3_998 VPWR VGND sg13g2_decap_8
XFILLER_49_72 VPWR VGND sg13g2_decap_8
XFILLER_2_497 VPWR VGND sg13g2_decap_8
XFILLER_38_608 VPWR VGND sg13g2_decap_8
XFILLER_1_35 VPWR VGND sg13g2_decap_8
XFILLER_46_630 VPWR VGND sg13g2_decap_8
XFILLER_19_877 VPWR VGND sg13g2_decap_8
XFILLER_18_387 VPWR VGND sg13g2_decap_8
XFILLER_33_346 VPWR VGND sg13g2_decap_8
X_1971_ VGND VPWR _0445_ _0447_ _0448_ net293 sg13g2_a21oi_1
XFILLER_41_390 VPWR VGND sg13g2_decap_8
X_2978__107 VPWR VGND net107 sg13g2_tiehi
X_2523_ falutop.i2c_inst.data_in\[12\] falutop.data_in\[12\] net319 _0040_ VPWR VGND
+ sg13g2_mux2_1
X_2454_ VGND VPWR _0744_ net321 _0016_ _0856_ sg13g2_a21oi_1
XFILLER_39_0 VPWR VGND sg13g2_decap_4
X_2385_ VGND VPWR net287 _0796_ _0006_ _0797_ sg13g2_a21oi_1
Xinput1 ui_in[0] net1 VPWR VGND sg13g2_buf_1
XFILLER_25_814 VPWR VGND sg13g2_decap_8
XFILLER_36_140 VPWR VGND sg13g2_decap_4
XFILLER_24_324 VPWR VGND sg13g2_decap_8
XFILLER_25_836 VPWR VGND sg13g2_fill_2
XFILLER_25_858 VPWR VGND sg13g2_decap_4
XFILLER_40_806 VPWR VGND sg13g2_fill_1
XFILLER_12_519 VPWR VGND sg13g2_decap_8
XFILLER_24_357 VPWR VGND sg13g2_decap_8
XFILLER_3_206 VPWR VGND sg13g2_decap_8
XFILLER_10_44 VPWR VGND sg13g2_fill_1
XFILLER_10_33 VPWR VGND sg13g2_decap_8
XFILLER_0_946 VPWR VGND sg13g2_decap_8
XFILLER_48_906 VPWR VGND sg13g2_decap_8
XFILLER_47_427 VPWR VGND sg13g2_decap_8
XFILLER_19_107 VPWR VGND sg13g2_decap_8
XFILLER_19_118 VPWR VGND sg13g2_fill_1
XFILLER_19_97 VPWR VGND sg13g2_decap_4
XFILLER_43_611 VPWR VGND sg13g2_decap_8
XFILLER_27_162 VPWR VGND sg13g2_decap_8
XFILLER_27_173 VPWR VGND sg13g2_decap_8
XFILLER_43_655 VPWR VGND sg13g2_fill_1
XFILLER_15_346 VPWR VGND sg13g2_decap_8
XFILLER_16_869 VPWR VGND sg13g2_decap_8
XFILLER_43_688 VPWR VGND sg13g2_decap_8
XFILLER_24_891 VPWR VGND sg13g2_decap_8
XFILLER_30_316 VPWR VGND sg13g2_decap_8
XFILLER_31_828 VPWR VGND sg13g2_decap_8
XFILLER_11_552 VPWR VGND sg13g2_decap_8
XFILLER_7_534 VPWR VGND sg13g2_decap_8
XFILLER_11_596 VPWR VGND sg13g2_fill_1
X_2938__102 VPWR VGND net102 sg13g2_tiehi
XFILLER_3_795 VPWR VGND sg13g2_decap_8
XFILLER_39_917 VPWR VGND sg13g2_decap_8
X_2170_ falutop.data_in\[3\] net295 _0636_ VPWR VGND sg13g2_nor2_1
XFILLER_47_994 VPWR VGND sg13g2_decap_8
XFILLER_19_652 VPWR VGND sg13g2_decap_8
XFILLER_46_482 VPWR VGND sg13g2_decap_4
XFILLER_18_173 VPWR VGND sg13g2_decap_8
XFILLER_33_110 VPWR VGND sg13g2_fill_2
XFILLER_34_622 VPWR VGND sg13g2_fill_2
XFILLER_15_891 VPWR VGND sg13g2_decap_8
X_1954_ _0431_ _0424_ _0430_ VPWR VGND sg13g2_xnor2_1
XFILLER_21_338 VPWR VGND sg13g2_decap_8
X_1885_ _0359_ _0362_ _0357_ _0364_ VPWR VGND _0363_ sg13g2_nand4_1
X_2506_ net195 net315 _0898_ VPWR VGND sg13g2_nor2_2
X_2437_ _0843_ net207 net289 VPWR VGND sg13g2_nand2_1
XFILLER_5_1028 VPWR VGND sg13g2_fill_1
XFILLER_5_1017 VPWR VGND sg13g2_decap_8
X_2368_ net190 _0776_ _0785_ VPWR VGND sg13g2_nor2_1
X_2299_ VGND VPWR net389 _0721_ _0142_ _0722_ sg13g2_a21oi_1
XFILLER_44_419 VPWR VGND sg13g2_decap_8
XFILLER_37_493 VPWR VGND sg13g2_fill_2
XFILLER_37_482 VPWR VGND sg13g2_fill_1
XFILLER_25_644 VPWR VGND sg13g2_decap_8
XFILLER_13_828 VPWR VGND sg13g2_decap_8
XFILLER_24_187 VPWR VGND sg13g2_decap_4
XFILLER_40_669 VPWR VGND sg13g2_decap_8
XFILLER_12_338 VPWR VGND sg13g2_decap_8
XFILLER_20_360 VPWR VGND sg13g2_decap_8
XFILLER_21_883 VPWR VGND sg13g2_decap_8
XFILLER_4_559 VPWR VGND sg13g2_decap_8
XFILLER_48_703 VPWR VGND sg13g2_decap_8
XFILLER_0_743 VPWR VGND sg13g2_decap_8
XFILLER_36_909 VPWR VGND sg13g2_decap_8
XFILLER_29_972 VPWR VGND sg13g2_decap_8
XFILLER_44_942 VPWR VGND sg13g2_decap_8
XFILLER_16_611 VPWR VGND sg13g2_decap_4
XFILLER_16_633 VPWR VGND sg13g2_decap_8
XFILLER_43_452 VPWR VGND sg13g2_decap_8
XFILLER_16_699 VPWR VGND sg13g2_decap_8
XFILLER_30_179 VPWR VGND sg13g2_decap_8
X_2905__167 VPWR VGND net167 sg13g2_tiehi
XFILLER_8_865 VPWR VGND sg13g2_decap_8
XFILLER_7_78 VPWR VGND sg13g2_decap_8
X_1670_ net353 net349 net363 net361 _0152_ VPWR VGND sg13g2_and4_1
XFILLER_7_386 VPWR VGND sg13g2_decap_8
XFILLER_3_592 VPWR VGND sg13g2_decap_8
XFILLER_39_703 VPWR VGND sg13g2_decap_8
XFILLER_38_202 VPWR VGND sg13g2_fill_2
X_2222_ _0667_ net383 falutop.data_in\[8\] VPWR VGND sg13g2_nand2_1
X_2153_ falutop.data_in\[8\] falutop.data_in\[9\] falutop.data_in\[10\] _0624_ VPWR
+ VGND sg13g2_nor3_1
XFILLER_47_791 VPWR VGND sg13g2_decap_8
X_2084_ _0556_ _0547_ _0558_ VPWR VGND sg13g2_xor2_1
XFILLER_35_920 VPWR VGND sg13g2_decap_8
XFILLER_34_441 VPWR VGND sg13g2_fill_2
XFILLER_34_452 VPWR VGND sg13g2_decap_4
XFILLER_34_474 VPWR VGND sg13g2_decap_8
XFILLER_35_997 VPWR VGND sg13g2_decap_8
XFILLER_22_658 VPWR VGND sg13g2_decap_8
X_2986_ net129 VGND VPWR _0143_ falutop.i2c_inst.data_in\[15\] net393 sg13g2_dfrbpq_1
XFILLER_21_146 VPWR VGND sg13g2_decap_4
X_1937_ VGND VPWR _0375_ _0390_ _0414_ _0389_ sg13g2_a21oi_1
X_1868_ _0347_ _0338_ _0346_ VPWR VGND sg13g2_xnor2_1
X_1799_ _0278_ _0277_ _0279_ VPWR VGND sg13g2_xor2_1
XFILLER_1_518 VPWR VGND sg13g2_decap_8
XFILLER_29_213 VPWR VGND sg13g2_decap_8
XFILLER_45_717 VPWR VGND sg13g2_fill_2
XFILLER_44_205 VPWR VGND sg13g2_decap_8
XFILLER_17_408 VPWR VGND sg13g2_decap_8
XFILLER_26_931 VPWR VGND sg13g2_decap_8
XFILLER_25_452 VPWR VGND sg13g2_decap_8
XFILLER_41_912 VPWR VGND sg13g2_decap_8
XFILLER_40_411 VPWR VGND sg13g2_fill_1
XFILLER_16_76 VPWR VGND sg13g2_fill_2
XFILLER_25_474 VPWR VGND sg13g2_decap_8
XFILLER_13_636 VPWR VGND sg13g2_decap_8
XFILLER_13_647 VPWR VGND sg13g2_fill_1
XFILLER_41_989 VPWR VGND sg13g2_decap_8
XFILLER_12_157 VPWR VGND sg13g2_fill_2
XFILLER_40_499 VPWR VGND sg13g2_decap_8
XFILLER_32_42 VPWR VGND sg13g2_decap_8
X_2946__71 VPWR VGND net71 sg13g2_tiehi
XFILLER_5_835 VPWR VGND sg13g2_decap_8
XFILLER_4_378 VPWR VGND sg13g2_fill_1
XFILLER_0_540 VPWR VGND sg13g2_decap_8
X_2859__78 VPWR VGND net78 sg13g2_tiehi
XFILLER_48_566 VPWR VGND sg13g2_fill_1
XFILLER_35_216 VPWR VGND sg13g2_decap_8
XFILLER_35_238 VPWR VGND sg13g2_decap_8
XFILLER_16_430 VPWR VGND sg13g2_decap_4
XFILLER_17_975 VPWR VGND sg13g2_decap_8
X_2840_ VGND VPWR _0970_ _1045_ _1178_ _1177_ sg13g2_a21oi_1
XFILLER_31_444 VPWR VGND sg13g2_decap_8
XFILLER_32_967 VPWR VGND sg13g2_decap_8
XFILLER_31_466 VPWR VGND sg13g2_decap_4
XFILLER_12_680 VPWR VGND sg13g2_decap_8
X_2771_ VGND VPWR _1018_ _1019_ _1110_ _1021_ sg13g2_a21oi_1
XFILLER_8_662 VPWR VGND sg13g2_decap_8
X_1722_ _0203_ _1345_ _0202_ VPWR VGND sg13g2_xnor2_1
Xhold106 falutop.div_inst.rem\[4\] VPWR VGND net413 sg13g2_dlygate4sd3_1
Xhold117 falutop.alu_data_in\[2\] VPWR VGND net424 sg13g2_dlygate4sd3_1
X_1653_ _1326_ _1335_ _1336_ VPWR VGND sg13g2_nor2_1
Xhold128 falutop.div_inst.start VPWR VGND net435 sg13g2_dlygate4sd3_1
X_1584_ _1268_ net350 net329 net363 VPWR VGND sg13g2_and3_1
XFILLER_39_511 VPWR VGND sg13g2_decap_8
X_2205_ _0629_ net384 _0655_ VPWR VGND sg13g2_nor2b_1
X_2136_ _0609_ falutop.div_inst.rem\[6\] _0608_ VPWR VGND sg13g2_xnor2_1
X_2067_ VGND VPWR _0505_ _0521_ _0541_ _0519_ sg13g2_a21oi_1
XFILLER_26_238 VPWR VGND sg13g2_decap_8
XFILLER_22_422 VPWR VGND sg13g2_decap_8
XFILLER_22_433 VPWR VGND sg13g2_fill_2
XFILLER_23_967 VPWR VGND sg13g2_decap_8
XFILLER_10_617 VPWR VGND sg13g2_decap_8
XFILLER_22_455 VPWR VGND sg13g2_decap_8
X_2969_ net141 VGND VPWR _0126_ falutop.div_inst.a\[6\] clknet_4_4_0_clk sg13g2_dfrbpq_1
XFILLER_22_499 VPWR VGND sg13g2_decap_8
XFILLER_2_805 VPWR VGND sg13g2_decap_8
XFILLER_45_503 VPWR VGND sg13g2_decap_8
XFILLER_18_728 VPWR VGND sg13g2_decap_8
XFILLER_45_569 VPWR VGND sg13g2_decap_8
XFILLER_45_558 VPWR VGND sg13g2_decap_4
XFILLER_17_238 VPWR VGND sg13g2_decap_8
XFILLER_14_901 VPWR VGND sg13g2_decap_8
XFILLER_25_260 VPWR VGND sg13g2_decap_4
XFILLER_13_411 VPWR VGND sg13g2_decap_8
XFILLER_13_422 VPWR VGND sg13g2_fill_2
XFILLER_43_63 VPWR VGND sg13g2_decap_8
XFILLER_14_978 VPWR VGND sg13g2_decap_8
XFILLER_40_274 VPWR VGND sg13g2_decap_8
Xheichips25_template_9 VPWR VGND uio_oe[4] sg13g2_tielo
XFILLER_5_632 VPWR VGND sg13g2_decap_8
XFILLER_4_142 VPWR VGND sg13g2_decap_8
XFILLER_4_153 VPWR VGND sg13g2_fill_1
XFILLER_1_882 VPWR VGND sg13g2_decap_8
XFILLER_49_853 VPWR VGND sg13g2_decap_8
XFILLER_48_330 VPWR VGND sg13g2_decap_8
XFILLER_36_547 VPWR VGND sg13g2_decap_8
XFILLER_17_772 VPWR VGND sg13g2_fill_1
XFILLER_17_1017 VPWR VGND sg13g2_decap_8
XFILLER_17_1028 VPWR VGND sg13g2_fill_1
XFILLER_20_915 VPWR VGND sg13g2_decap_8
XFILLER_32_764 VPWR VGND sg13g2_fill_2
XFILLER_32_775 VPWR VGND sg13g2_decap_8
X_2823_ _1105_ _1160_ _1161_ VPWR VGND sg13g2_and2_1
X_2754_ net339 net284 _1093_ VPWR VGND sg13g2_nor2_1
X_1705_ net318 _1321_ net219 _0187_ VPWR VGND sg13g2_nand3_1
X_2685_ _1025_ _1023_ _1024_ VPWR VGND sg13g2_nand2_1
X_1636_ net318 _1259_ net238 _1320_ VPWR VGND sg13g2_nand3_1
X_1567_ _1249_ _1250_ _1237_ _1252_ VPWR VGND sg13g2_nand3_1
Xfanout405 net406 net405 VPWR VGND sg13g2_buf_8
X_1498_ VGND VPWR _1034_ _1096_ _1184_ _1032_ sg13g2_a21oi_1
XFILLER_39_385 VPWR VGND sg13g2_decap_8
X_2119_ _0592_ _0545_ _0591_ VPWR VGND sg13g2_xnor2_1
XFILLER_42_539 VPWR VGND sg13g2_decap_8
XFILLER_11_904 VPWR VGND sg13g2_decap_8
XFILLER_22_252 VPWR VGND sg13g2_decap_4
XFILLER_13_33 VPWR VGND sg13g2_fill_1
XFILLER_23_797 VPWR VGND sg13g2_fill_1
XFILLER_10_436 VPWR VGND sg13g2_fill_1
XFILLER_7_919 VPWR VGND sg13g2_decap_8
XFILLER_2_602 VPWR VGND sg13g2_decap_8
XFILLER_8_4 VPWR VGND sg13g2_decap_8
X_2971__135 VPWR VGND net135 sg13g2_tiehi
XFILLER_2_679 VPWR VGND sg13g2_decap_8
XFILLER_49_149 VPWR VGND sg13g2_decap_8
XFILLER_46_834 VPWR VGND sg13g2_decap_8
XFILLER_38_85 VPWR VGND sg13g2_decap_4
XFILLER_45_333 VPWR VGND sg13g2_decap_8
XFILLER_18_547 VPWR VGND sg13g2_decap_4
XFILLER_6_930 VPWR VGND sg13g2_decap_8
XFILLER_10_981 VPWR VGND sg13g2_decap_8
X_2470_ falutop.i2c_inst.state\[1\] falutop.i2c_inst.state\[0\] _0868_ VPWR VGND sg13g2_nor2b_2
XFILLER_49_650 VPWR VGND sg13g2_decap_8
XFILLER_36_311 VPWR VGND sg13g2_decap_8
XFILLER_37_845 VPWR VGND sg13g2_decap_8
XFILLER_24_539 VPWR VGND sg13g2_decap_8
XFILLER_20_712 VPWR VGND sg13g2_fill_1
XFILLER_32_583 VPWR VGND sg13g2_fill_1
Xclkload9 VPWR clkload9/Y clknet_4_11_0_clk VGND sg13g2_inv_1
X_2806_ _1083_ _1087_ _1144_ VPWR VGND sg13g2_nor2_1
XFILLER_30_1014 VPWR VGND sg13g2_decap_8
X_2737_ _1077_ _0997_ _1076_ VPWR VGND sg13g2_nand2_1
X_2668_ _1006_ _0971_ _1008_ VPWR VGND sg13g2_xor2_1
X_1619_ _1303_ net349 net366 VPWR VGND sg13g2_nand2_1
X_2599_ net405 VPWR _0944_ VGND net415 net313 sg13g2_o21ai_1
XFILLER_8_1026 VPWR VGND sg13g2_fill_2
XFILLER_47_609 VPWR VGND sg13g2_decap_8
Xfanout279 _0991_ net279 VPWR VGND sg13g2_buf_8
XFILLER_28_834 VPWR VGND sg13g2_decap_8
XFILLER_39_171 VPWR VGND sg13g2_decap_8
XFILLER_27_322 VPWR VGND sg13g2_decap_8
XFILLER_28_867 VPWR VGND sg13g2_fill_1
XFILLER_43_815 VPWR VGND sg13g2_decap_8
XFILLER_42_303 VPWR VGND sg13g2_decap_8
XFILLER_27_366 VPWR VGND sg13g2_decap_8
XFILLER_27_377 VPWR VGND sg13g2_decap_8
XFILLER_15_539 VPWR VGND sg13g2_decap_8
XFILLER_11_701 VPWR VGND sg13g2_decap_8
XFILLER_23_561 VPWR VGND sg13g2_decap_8
XFILLER_24_76 VPWR VGND sg13g2_decap_4
XFILLER_7_716 VPWR VGND sg13g2_decap_8
XFILLER_11_778 VPWR VGND sg13g2_decap_8
XFILLER_40_42 VPWR VGND sg13g2_decap_8
XFILLER_6_237 VPWR VGND sg13g2_decap_8
XFILLER_3_900 VPWR VGND sg13g2_decap_8
XFILLER_3_977 VPWR VGND sg13g2_decap_8
XFILLER_2_476 VPWR VGND sg13g2_decap_8
XFILLER_1_14 VPWR VGND sg13g2_decap_8
XFILLER_19_801 VPWR VGND sg13g2_fill_2
XFILLER_18_333 VPWR VGND sg13g2_decap_8
XFILLER_19_856 VPWR VGND sg13g2_decap_8
XFILLER_45_152 VPWR VGND sg13g2_decap_8
XFILLER_34_804 VPWR VGND sg13g2_fill_1
XFILLER_34_815 VPWR VGND sg13g2_decap_8
XFILLER_45_174 VPWR VGND sg13g2_decap_8
X_1970_ _0401_ _0320_ _0446_ _0447_ VPWR VGND sg13g2_a21o_1
X_2522_ falutop.i2c_inst.data_in\[11\] falutop.data_in\[11\] net319 _0039_ VPWR VGND
+ sg13g2_mux2_1
X_2453_ falutop.i2c_inst.data_in\[16\] net321 _0856_ VPWR VGND sg13g2_nor2_1
X_2384_ net180 net287 _0797_ VPWR VGND sg13g2_nor2_1
Xinput2 ui_in[1] net2 VPWR VGND sg13g2_buf_2
XFILLER_49_491 VPWR VGND sg13g2_decap_8
XFILLER_37_686 VPWR VGND sg13g2_decap_8
XFILLER_36_152 VPWR VGND sg13g2_fill_1
XFILLER_33_870 VPWR VGND sg13g2_fill_1
XFILLER_20_553 VPWR VGND sg13g2_fill_1
XFILLER_10_89 VPWR VGND sg13g2_decap_8
XFILLER_0_925 VPWR VGND sg13g2_decap_8
XFILLER_47_406 VPWR VGND sg13g2_fill_2
XFILLER_19_54 VPWR VGND sg13g2_decap_4
XFILLER_28_642 VPWR VGND sg13g2_decap_8
XFILLER_27_141 VPWR VGND sg13g2_decap_8
XFILLER_43_634 VPWR VGND sg13g2_decap_8
XFILLER_15_325 VPWR VGND sg13g2_decap_8
XFILLER_16_848 VPWR VGND sg13g2_decap_8
XFILLER_28_686 VPWR VGND sg13g2_decap_8
XFILLER_42_177 VPWR VGND sg13g2_fill_2
XFILLER_7_513 VPWR VGND sg13g2_decap_8
XFILLER_3_774 VPWR VGND sg13g2_decap_8
XFILLER_32_8 VPWR VGND sg13g2_fill_2
XFILLER_20_1013 VPWR VGND sg13g2_decap_8
XFILLER_47_973 VPWR VGND sg13g2_decap_8
XFILLER_46_461 VPWR VGND sg13g2_decap_8
XFILLER_18_152 VPWR VGND sg13g2_decap_8
XFILLER_22_818 VPWR VGND sg13g2_decap_4
XFILLER_33_144 VPWR VGND sg13g2_decap_4
XFILLER_34_645 VPWR VGND sg13g2_decap_4
XFILLER_15_870 VPWR VGND sg13g2_decap_8
XFILLER_21_317 VPWR VGND sg13g2_decap_8
XFILLER_33_177 VPWR VGND sg13g2_decap_8
X_1953_ _0430_ _0426_ _0427_ VPWR VGND sg13g2_xnor2_1
X_1884_ _1038_ VPWR _0363_ VGND _0297_ _0299_ sg13g2_o21ai_1
XFILLER_30_895 VPWR VGND sg13g2_decap_8
X_2505_ _0744_ falutop.i2c_inst.op\[1\] _0745_ _0746_ _0897_ VPWR VGND sg13g2_or4_1
X_2436_ _0839_ VPWR _0012_ VGND _0768_ _0842_ sg13g2_o21ai_1
X_2367_ VGND VPWR net388 net176 _0784_ _0783_ sg13g2_a21oi_1
X_2298_ net401 VPWR _0722_ VGND falutop.i2c_inst.data_in\[14\] _0721_ sg13g2_o21ai_1
XFILLER_38_995 VPWR VGND sg13g2_decap_8
XFILLER_13_807 VPWR VGND sg13g2_decap_8
XFILLER_40_604 VPWR VGND sg13g2_decap_8
XFILLER_24_155 VPWR VGND sg13g2_fill_1
XFILLER_24_166 VPWR VGND sg13g2_fill_2
XFILLER_21_44 VPWR VGND sg13g2_fill_1
XFILLER_4_538 VPWR VGND sg13g2_decap_8
XFILLER_0_722 VPWR VGND sg13g2_decap_8
XFILLER_0_799 VPWR VGND sg13g2_decap_8
XFILLER_48_759 VPWR VGND sg13g2_decap_8
XFILLER_47_236 VPWR VGND sg13g2_decap_8
XFILLER_29_951 VPWR VGND sg13g2_decap_8
XFILLER_44_921 VPWR VGND sg13g2_decap_8
XFILLER_28_483 VPWR VGND sg13g2_decap_8
XFILLER_43_431 VPWR VGND sg13g2_decap_8
XFILLER_44_998 VPWR VGND sg13g2_decap_8
XFILLER_15_166 VPWR VGND sg13g2_decap_8
XFILLER_31_604 VPWR VGND sg13g2_decap_8
XFILLER_30_158 VPWR VGND sg13g2_decap_8
XFILLER_8_844 VPWR VGND sg13g2_decap_8
XFILLER_7_46 VPWR VGND sg13g2_decap_4
XFILLER_12_884 VPWR VGND sg13g2_decap_8
XFILLER_7_365 VPWR VGND sg13g2_decap_8
XFILLER_3_571 VPWR VGND sg13g2_decap_8
X_2221_ net201 net301 _0666_ VPWR VGND sg13g2_nor2_1
XFILLER_30_5 VPWR VGND sg13g2_decap_8
XFILLER_23_4 VPWR VGND sg13g2_decap_8
XFILLER_38_214 VPWR VGND sg13g2_fill_2
X_2152_ VGND VPWR _0619_ _0622_ _0094_ _0623_ sg13g2_a21oi_1
X_2083_ _0556_ _0547_ _0557_ VPWR VGND sg13g2_nor2b_1
XFILLER_47_770 VPWR VGND sg13g2_decap_8
XFILLER_34_420 VPWR VGND sg13g2_decap_8
XFILLER_35_976 VPWR VGND sg13g2_decap_8
XFILLER_21_125 VPWR VGND sg13g2_decap_8
XFILLER_22_637 VPWR VGND sg13g2_decap_4
X_2985_ net93 VGND VPWR _0142_ falutop.i2c_inst.data_in\[14\] net393 sg13g2_dfrbpq_1
X_1936_ _0372_ VPWR _0413_ VGND _0328_ _0373_ sg13g2_o21ai_1
XFILLER_30_692 VPWR VGND sg13g2_fill_1
X_1867_ _0346_ _0339_ _0344_ VPWR VGND sg13g2_xnor2_1
X_1798_ _0278_ net353 net357 VPWR VGND sg13g2_nand2_1
XFILLER_27_1008 VPWR VGND sg13g2_decap_8
X_2419_ _0829_ net282 _0828_ VPWR VGND sg13g2_nand2_1
XFILLER_29_269 VPWR VGND sg13g2_decap_8
XFILLER_26_910 VPWR VGND sg13g2_decap_8
XFILLER_25_431 VPWR VGND sg13g2_decap_8
XFILLER_16_55 VPWR VGND sg13g2_decap_8
XFILLER_26_987 VPWR VGND sg13g2_decap_8
XFILLER_41_968 VPWR VGND sg13g2_decap_8
XFILLER_40_445 VPWR VGND sg13g2_decap_4
XFILLER_12_136 VPWR VGND sg13g2_decap_8
XFILLER_12_169 VPWR VGND sg13g2_decap_4
XFILLER_32_21 VPWR VGND sg13g2_decap_8
XFILLER_40_489 VPWR VGND sg13g2_fill_1
XFILLER_5_814 VPWR VGND sg13g2_decap_8
XFILLER_10_1023 VPWR VGND sg13g2_decap_4
XFILLER_48_501 VPWR VGND sg13g2_fill_2
XFILLER_0_596 VPWR VGND sg13g2_decap_8
XFILLER_17_954 VPWR VGND sg13g2_decap_8
XFILLER_16_464 VPWR VGND sg13g2_decap_8
XFILLER_16_475 VPWR VGND sg13g2_decap_8
XFILLER_31_401 VPWR VGND sg13g2_decap_8
XFILLER_44_795 VPWR VGND sg13g2_decap_8
XFILLER_43_294 VPWR VGND sg13g2_decap_4
XFILLER_31_423 VPWR VGND sg13g2_decap_8
XFILLER_32_946 VPWR VGND sg13g2_decap_8
X_2770_ _1109_ _0977_ _1043_ VPWR VGND sg13g2_nand2_1
XFILLER_31_489 VPWR VGND sg13g2_fill_1
XFILLER_8_641 VPWR VGND sg13g2_decap_8
XFILLER_11_191 VPWR VGND sg13g2_decap_4
X_1721_ _0200_ _0195_ _0202_ VPWR VGND sg13g2_xor2_1
Xhold107 falutop.div_inst.rem\[6\] VPWR VGND net414 sg13g2_dlygate4sd3_1
X_1652_ _1335_ _1327_ _1334_ VPWR VGND sg13g2_xnor2_1
Xhold118 falutop.i2c_inst.result\[4\] VPWR VGND net425 sg13g2_dlygate4sd3_1
X_2952__42 VPWR VGND net42 sg13g2_tiehi
Xhold129 falutop.alu_data_in\[11\] VPWR VGND net436 sg13g2_dlygate4sd3_1
X_1583_ _1247_ VPWR _1267_ VGND _1238_ _1248_ sg13g2_o21ai_1
XFILLER_39_523 VPWR VGND sg13g2_decap_8
X_2204_ net234 net302 _0654_ VPWR VGND sg13g2_nor2_1
X_2135_ _0608_ net381 _0577_ VPWR VGND sg13g2_nand2_1
X_2066_ _0540_ _0539_ _0091_ VPWR VGND sg13g2_nor2b_1
XFILLER_34_261 VPWR VGND sg13g2_decap_8
XFILLER_35_784 VPWR VGND sg13g2_fill_2
XFILLER_23_946 VPWR VGND sg13g2_decap_8
XFILLER_34_272 VPWR VGND sg13g2_fill_2
XFILLER_22_478 VPWR VGND sg13g2_decap_8
X_2968_ net143 VGND VPWR _0125_ falutop.div_inst.a\[5\] clknet_4_5_0_clk sg13g2_dfrbpq_1
XFILLER_31_990 VPWR VGND sg13g2_decap_8
XFILLER_33_1023 VPWR VGND sg13g2_decap_4
X_1919_ _0395_ _0396_ _0397_ VPWR VGND sg13g2_nor2_1
X_2899_ net173 VGND VPWR _0056_ falutop.div_inst.b1\[2\] clknet_4_0_0_clk sg13g2_dfrbpq_1
XFILLER_18_707 VPWR VGND sg13g2_fill_2
XFILLER_17_217 VPWR VGND sg13g2_decap_4
XFILLER_27_76 VPWR VGND sg13g2_decap_8
XFILLER_41_710 VPWR VGND sg13g2_decap_8
XFILLER_27_98 VPWR VGND sg13g2_decap_8
XFILLER_14_957 VPWR VGND sg13g2_decap_8
XFILLER_25_294 VPWR VGND sg13g2_fill_1
XFILLER_43_42 VPWR VGND sg13g2_decap_8
XFILLER_41_754 VPWR VGND sg13g2_fill_1
XFILLER_40_253 VPWR VGND sg13g2_decap_8
XFILLER_5_611 VPWR VGND sg13g2_decap_8
XFILLER_5_688 VPWR VGND sg13g2_decap_8
XFILLER_4_25 VPWR VGND sg13g2_decap_8
XFILLER_4_187 VPWR VGND sg13g2_fill_1
XFILLER_4_36 VPWR VGND sg13g2_fill_2
XFILLER_1_861 VPWR VGND sg13g2_decap_8
XFILLER_49_832 VPWR VGND sg13g2_decap_8
XFILLER_0_393 VPWR VGND sg13g2_decap_8
XFILLER_48_375 VPWR VGND sg13g2_decap_8
XFILLER_17_751 VPWR VGND sg13g2_decap_8
XFILLER_16_283 VPWR VGND sg13g2_decap_4
XFILLER_32_710 VPWR VGND sg13g2_decap_8
XFILLER_32_743 VPWR VGND sg13g2_decap_8
X_2822_ _1160_ _1147_ _1159_ VPWR VGND sg13g2_xnor2_1
X_2753_ _1020_ _1091_ _1092_ VPWR VGND sg13g2_nor2_1
XFILLER_9_994 VPWR VGND sg13g2_decap_8
X_1704_ _1321_ net318 net219 _0186_ VPWR VGND sg13g2_a21o_1
X_2684_ net325 VPWR _1024_ VGND _0749_ net348 sg13g2_o21ai_1
X_1635_ _1286_ _1318_ _1265_ _1319_ VPWR VGND sg13g2_nand3_1
X_1566_ _1251_ _1237_ _1249_ _1250_ VPWR VGND sg13g2_and3_1
Xfanout406 net410 net406 VPWR VGND sg13g2_buf_8
X_1497_ VGND VPWR _1115_ _1174_ _1183_ _1182_ sg13g2_a21oi_1
XFILLER_39_331 VPWR VGND sg13g2_decap_8
XFILLER_39_364 VPWR VGND sg13g2_decap_8
X_2118_ _0589_ _0584_ _0591_ VPWR VGND sg13g2_xor2_1
XFILLER_27_548 VPWR VGND sg13g2_fill_2
X_2049_ _0524_ _0523_ _0460_ VPWR VGND sg13g2_nand2b_1
XFILLER_42_518 VPWR VGND sg13g2_decap_8
XFILLER_23_732 VPWR VGND sg13g2_fill_2
XFILLER_22_231 VPWR VGND sg13g2_decap_8
XFILLER_10_415 VPWR VGND sg13g2_decap_8
XFILLER_13_78 VPWR VGND sg13g2_decap_8
X_2901__171 VPWR VGND net171 sg13g2_tiehi
XFILLER_2_658 VPWR VGND sg13g2_decap_8
XFILLER_49_128 VPWR VGND sg13g2_decap_8
XFILLER_38_42 VPWR VGND sg13g2_decap_8
XFILLER_46_813 VPWR VGND sg13g2_decap_8
XFILLER_45_312 VPWR VGND sg13g2_decap_8
XFILLER_38_64 VPWR VGND sg13g2_decap_8
XFILLER_13_231 VPWR VGND sg13g2_decap_8
XFILLER_9_202 VPWR VGND sg13g2_fill_1
XFILLER_9_257 VPWR VGND sg13g2_decap_4
XFILLER_10_960 VPWR VGND sg13g2_decap_8
XFILLER_6_986 VPWR VGND sg13g2_decap_8
XFILLER_5_485 VPWR VGND sg13g2_decap_8
XFILLER_48_161 VPWR VGND sg13g2_decap_4
XFILLER_36_356 VPWR VGND sg13g2_decap_8
XFILLER_36_378 VPWR VGND sg13g2_decap_8
XFILLER_32_540 VPWR VGND sg13g2_fill_2
X_2805_ _1142_ _1087_ _1143_ VPWR VGND sg13g2_nor2b_1
XFILLER_20_735 VPWR VGND sg13g2_fill_1
XFILLER_8_290 VPWR VGND sg13g2_fill_2
XFILLER_9_791 VPWR VGND sg13g2_decap_8
X_2736_ VPWR VGND _1035_ _1075_ _1032_ _1014_ _1076_ _1016_ sg13g2_a221oi_1
X_2667_ _0971_ _1006_ _1007_ VPWR VGND sg13g2_and2_1
X_1618_ _1301_ _1200_ _1302_ VPWR VGND sg13g2_xor2_1
XFILLER_8_1005 VPWR VGND sg13g2_decap_8
X_2598_ VGND VPWR _0834_ net313 _0073_ net417 sg13g2_a21oi_1
X_1549_ _1234_ _1231_ _1233_ _1230_ _1229_ VPWR VGND sg13g2_a22oi_1
XFILLER_28_802 VPWR VGND sg13g2_fill_1
XFILLER_42_359 VPWR VGND sg13g2_decap_8
XFILLER_10_201 VPWR VGND sg13g2_decap_8
XFILLER_24_55 VPWR VGND sg13g2_decap_8
XFILLER_11_757 VPWR VGND sg13g2_decap_8
XFILLER_10_256 VPWR VGND sg13g2_fill_1
XFILLER_6_216 VPWR VGND sg13g2_decap_8
XFILLER_40_21 VPWR VGND sg13g2_decap_8
XFILLER_40_98 VPWR VGND sg13g2_decap_8
XFILLER_3_956 VPWR VGND sg13g2_decap_8
XFILLER_2_455 VPWR VGND sg13g2_decap_8
XFILLER_49_63 VPWR VGND sg13g2_decap_4
XFILLER_45_120 VPWR VGND sg13g2_decap_4
XFILLER_18_312 VPWR VGND sg13g2_decap_8
XFILLER_46_665 VPWR VGND sg13g2_decap_8
XFILLER_18_367 VPWR VGND sg13g2_decap_4
XFILLER_34_849 VPWR VGND sg13g2_decap_8
XFILLER_42_893 VPWR VGND sg13g2_decap_8
XFILLER_14_584 VPWR VGND sg13g2_fill_1
X_2521_ falutop.i2c_inst.data_in\[10\] falutop.data_in\[10\] net319 _0038_ VPWR VGND
+ sg13g2_mux2_1
XFILLER_6_783 VPWR VGND sg13g2_decap_8
X_2452_ falutop.i2c_inst.state\[0\] net401 falutop.i2c_inst.state\[1\] _0855_ VPWR
+ VGND sg13g2_nand3_1
XFILLER_5_293 VPWR VGND sg13g2_decap_8
X_2383_ VGND VPWR net385 falutop.div_inst.a\[6\] _0796_ _0795_ sg13g2_a21oi_1
X_2915__148 VPWR VGND net148 sg13g2_tiehi
XFILLER_37_610 VPWR VGND sg13g2_decap_4
Xinput3 ui_in[3] net3 VPWR VGND sg13g2_buf_1
XFILLER_37_665 VPWR VGND sg13g2_decap_8
XFILLER_25_838 VPWR VGND sg13g2_fill_1
XFILLER_40_819 VPWR VGND sg13g2_decap_8
X_2961__157 VPWR VGND net157 sg13g2_tiehi
XFILLER_20_521 VPWR VGND sg13g2_decap_8
XFILLER_20_598 VPWR VGND sg13g2_decap_8
X_2719_ net324 VPWR _1059_ VGND net336 _0753_ sg13g2_o21ai_1
XFILLER_10_79 VPWR VGND sg13g2_decap_4
XFILLER_0_904 VPWR VGND sg13g2_decap_8
XFILLER_19_33 VPWR VGND sg13g2_fill_2
XFILLER_28_665 VPWR VGND sg13g2_decap_8
XFILLER_16_827 VPWR VGND sg13g2_decap_8
XFILLER_42_134 VPWR VGND sg13g2_fill_1
XFILLER_24_860 VPWR VGND sg13g2_fill_1
XFILLER_11_510 VPWR VGND sg13g2_fill_1
XFILLER_13_1010 VPWR VGND sg13g2_decap_8
XFILLER_11_587 VPWR VGND sg13g2_decap_8
XFILLER_7_569 VPWR VGND sg13g2_decap_8
XFILLER_3_753 VPWR VGND sg13g2_decap_8
XFILLER_2_263 VPWR VGND sg13g2_decap_8
XFILLER_2_274 VPWR VGND sg13g2_fill_2
XFILLER_2_285 VPWR VGND sg13g2_fill_2
XFILLER_19_621 VPWR VGND sg13g2_decap_8
XFILLER_47_952 VPWR VGND sg13g2_decap_8
XFILLER_18_131 VPWR VGND sg13g2_decap_8
XFILLER_34_602 VPWR VGND sg13g2_fill_2
XFILLER_33_123 VPWR VGND sg13g2_decap_8
X_1952_ _0425_ _0427_ _0429_ VPWR VGND sg13g2_nor2_1
X_1883_ _0361_ VPWR _0362_ VGND net375 net280 sg13g2_o21ai_1
XFILLER_30_874 VPWR VGND sg13g2_decap_8
XFILLER_6_580 VPWR VGND sg13g2_decap_8
XFILLER_44_0 VPWR VGND sg13g2_decap_8
X_2504_ _0744_ falutop.i2c_inst.op\[1\] _0745_ _0746_ _0896_ VPWR VGND sg13g2_nor4_1
X_2435_ _0841_ VPWR _0842_ VGND net202 net283 sg13g2_o21ai_1
X_2366_ _0737_ net387 _0783_ VPWR VGND sg13g2_nor2_1
XFILLER_29_407 VPWR VGND sg13g2_decap_8
XFILLER_29_418 VPWR VGND sg13g2_fill_2
X_2297_ _0692_ _0716_ _0721_ VPWR VGND sg13g2_nor2_1
XFILLER_29_429 VPWR VGND sg13g2_decap_8
XFILLER_38_974 VPWR VGND sg13g2_decap_8
XFILLER_37_451 VPWR VGND sg13g2_decap_8
XFILLER_25_613 VPWR VGND sg13g2_decap_8
XFILLER_25_624 VPWR VGND sg13g2_fill_1
XFILLER_24_134 VPWR VGND sg13g2_decap_8
XFILLER_36_1021 VPWR VGND sg13g2_decap_8
XFILLER_12_318 VPWR VGND sg13g2_decap_8
XFILLER_25_679 VPWR VGND sg13g2_decap_8
XFILLER_21_841 VPWR VGND sg13g2_decap_8
XFILLER_4_517 VPWR VGND sg13g2_decap_8
XFILLER_0_701 VPWR VGND sg13g2_decap_8
XFILLER_43_1025 VPWR VGND sg13g2_decap_4
XFILLER_0_778 VPWR VGND sg13g2_decap_8
XFILLER_48_738 VPWR VGND sg13g2_decap_8
XFILLER_47_215 VPWR VGND sg13g2_decap_8
XFILLER_29_930 VPWR VGND sg13g2_decap_8
XFILLER_46_42 VPWR VGND sg13g2_fill_2
XFILLER_44_900 VPWR VGND sg13g2_decap_8
XFILLER_46_75 VPWR VGND sg13g2_decap_8
XFILLER_43_410 VPWR VGND sg13g2_decap_8
XFILLER_28_462 VPWR VGND sg13g2_decap_8
XFILLER_44_977 VPWR VGND sg13g2_decap_8
XFILLER_16_668 VPWR VGND sg13g2_decap_8
XFILLER_15_145 VPWR VGND sg13g2_decap_8
XFILLER_15_156 VPWR VGND sg13g2_fill_1
XFILLER_16_679 VPWR VGND sg13g2_decap_8
XFILLER_30_104 VPWR VGND sg13g2_fill_2
XFILLER_8_823 VPWR VGND sg13g2_decap_8
XFILLER_12_863 VPWR VGND sg13g2_decap_8
XFILLER_7_14 VPWR VGND sg13g2_fill_2
X_2956__29 VPWR VGND net29 sg13g2_tiehi
XFILLER_3_550 VPWR VGND sg13g2_decap_8
X_2220_ falutop.data_in\[8\] net227 net299 _0120_ VPWR VGND sg13g2_mux2_1
XFILLER_39_749 VPWR VGND sg13g2_decap_8
XFILLER_16_4 VPWR VGND sg13g2_decap_4
X_2151_ net407 VPWR _0623_ VGND net250 net304 sg13g2_o21ai_1
X_2082_ _0556_ _0509_ _0554_ VPWR VGND sg13g2_xnor2_1
XFILLER_19_462 VPWR VGND sg13g2_decap_4
XFILLER_46_281 VPWR VGND sg13g2_fill_2
XFILLER_35_955 VPWR VGND sg13g2_decap_8
X_2984_ net109 VGND VPWR _0141_ falutop.i2c_inst.data_in\[13\] net393 sg13g2_dfrbpq_1
XFILLER_15_690 VPWR VGND sg13g2_decap_8
XFILLER_21_104 VPWR VGND sg13g2_decap_8
X_1935_ VGND VPWR _0407_ _0411_ _0088_ _0412_ sg13g2_a21oi_1
X_1866_ _0345_ _0339_ _0344_ VPWR VGND sg13g2_nand2_1
X_1797_ _0277_ net340 net367 VPWR VGND sg13g2_nand2_1
X_2418_ _0828_ _0809_ _0810_ VPWR VGND sg13g2_xnor2_1
X_2349_ _0768_ _0765_ VPWR VGND _0766_ sg13g2_nand2b_2
XFILLER_29_248 VPWR VGND sg13g2_decap_8
XFILLER_37_270 VPWR VGND sg13g2_decap_8
XFILLER_16_23 VPWR VGND sg13g2_decap_8
XFILLER_26_966 VPWR VGND sg13g2_decap_8
XFILLER_13_605 VPWR VGND sg13g2_fill_2
XFILLER_41_947 VPWR VGND sg13g2_decap_8
XFILLER_40_424 VPWR VGND sg13g2_decap_8
XFILLER_9_609 VPWR VGND sg13g2_decap_8
XFILLER_21_671 VPWR VGND sg13g2_decap_8
XFILLER_21_682 VPWR VGND sg13g2_fill_2
XFILLER_10_1002 VPWR VGND sg13g2_decap_8
XFILLER_4_358 VPWR VGND sg13g2_decap_8
X_2974__123 VPWR VGND net123 sg13g2_tiehi
XFILLER_0_575 VPWR VGND sg13g2_decap_8
XFILLER_17_933 VPWR VGND sg13g2_decap_8
XFILLER_29_793 VPWR VGND sg13g2_fill_2
XFILLER_44_774 VPWR VGND sg13g2_decap_8
XFILLER_32_925 VPWR VGND sg13g2_decap_8
XFILLER_43_273 VPWR VGND sg13g2_decap_8
XFILLER_8_620 VPWR VGND sg13g2_decap_8
X_1720_ _0201_ _0200_ _0195_ VPWR VGND sg13g2_nand2b_1
XFILLER_8_697 VPWR VGND sg13g2_decap_8
XFILLER_7_163 VPWR VGND sg13g2_decap_8
Xhold108 falutop.div_inst.rem\[3\] VPWR VGND net415 sg13g2_dlygate4sd3_1
X_1651_ _1332_ _1331_ _1334_ VPWR VGND sg13g2_xor2_1
Xhold119 _1324_ VPWR VGND net426 sg13g2_dlygate4sd3_1
X_1582_ _1266_ net343 net337 VPWR VGND sg13g2_nand2_1
XFILLER_4_881 VPWR VGND sg13g2_decap_8
XFILLER_3_380 VPWR VGND sg13g2_fill_2
X_2203_ VGND VPWR net302 _0653_ _0115_ _0651_ sg13g2_a21oi_1
X_2134_ net291 VPWR _0607_ VGND _0603_ _0606_ sg13g2_o21ai_1
XFILLER_27_708 VPWR VGND sg13g2_decap_8
XFILLER_39_579 VPWR VGND sg13g2_decap_4
X_2858__80 VPWR VGND net80 sg13g2_tiehi
XFILLER_47_590 VPWR VGND sg13g2_decap_8
X_2065_ net410 VPWR _0540_ VGND net273 net306 sg13g2_o21ai_1
XFILLER_19_281 VPWR VGND sg13g2_decap_8
XFILLER_35_730 VPWR VGND sg13g2_decap_8
XFILLER_23_925 VPWR VGND sg13g2_decap_8
XFILLER_35_763 VPWR VGND sg13g2_decap_8
XFILLER_22_402 VPWR VGND sg13g2_decap_4
XFILLER_33_1002 VPWR VGND sg13g2_decap_8
X_2967_ net145 VGND VPWR _0124_ falutop.div_inst.a\[4\] clknet_4_5_0_clk sg13g2_dfrbpq_1
X_2898_ net174 VGND VPWR _0055_ falutop.div_inst.b1\[1\] clknet_4_0_0_clk sg13g2_dfrbpq_1
X_1918_ VGND VPWR _0322_ _0352_ _0396_ _0351_ sg13g2_a21oi_1
X_1849_ net371 _0261_ falutop.alu_data_in\[14\] _0328_ VPWR VGND sg13g2_nand3_1
XFILLER_40_1028 VPWR VGND sg13g2_fill_1
XFILLER_40_1017 VPWR VGND sg13g2_decap_8
X_2864__72 VPWR VGND net72 sg13g2_tiehi
XFILLER_43_21 VPWR VGND sg13g2_decap_8
XFILLER_14_936 VPWR VGND sg13g2_decap_8
XFILLER_26_796 VPWR VGND sg13g2_decap_8
XFILLER_40_232 VPWR VGND sg13g2_decap_8
XFILLER_22_991 VPWR VGND sg13g2_decap_8
XFILLER_5_667 VPWR VGND sg13g2_decap_8
XFILLER_1_840 VPWR VGND sg13g2_decap_8
XFILLER_49_811 VPWR VGND sg13g2_decap_8
XFILLER_0_372 VPWR VGND sg13g2_decap_8
XFILLER_49_888 VPWR VGND sg13g2_decap_8
XFILLER_36_505 VPWR VGND sg13g2_decap_8
XFILLER_36_516 VPWR VGND sg13g2_fill_2
XFILLER_1_1022 VPWR VGND sg13g2_decap_8
XFILLER_17_785 VPWR VGND sg13g2_decap_8
XFILLER_31_210 VPWR VGND sg13g2_decap_8
XFILLER_31_232 VPWR VGND sg13g2_decap_8
XFILLER_31_243 VPWR VGND sg13g2_decap_8
XFILLER_32_766 VPWR VGND sg13g2_fill_1
X_2821_ _1156_ _1158_ _1159_ VPWR VGND sg13g2_nor2_1
X_2752_ _1090_ VPWR _1091_ VGND _0751_ net284 sg13g2_o21ai_1
XFILLER_9_973 VPWR VGND sg13g2_decap_8
X_1703_ _0173_ _0184_ _1343_ _0185_ VPWR VGND sg13g2_nand3_1
XFILLER_8_494 VPWR VGND sg13g2_decap_8
X_2683_ _1017_ _1019_ _1023_ VPWR VGND sg13g2_and2_1
X_1634_ VPWR VGND _1317_ _1297_ _1316_ _1287_ _1318_ _1288_ sg13g2_a221oi_1
X_1565_ _1238_ VPWR _1250_ VGND _1246_ _1248_ sg13g2_o21ai_1
Xfanout407 net408 net407 VPWR VGND sg13g2_buf_8
XFILLER_39_310 VPWR VGND sg13g2_decap_8
X_1496_ _1178_ _1180_ _1176_ _1182_ VPWR VGND _1181_ sg13g2_nand4_1
XFILLER_27_527 VPWR VGND sg13g2_decap_8
X_2117_ _0584_ _0589_ _0590_ VPWR VGND sg13g2_and2_1
X_2048_ _0522_ _0502_ _0523_ VPWR VGND sg13g2_xor2_1
X_2925__128 VPWR VGND net128 sg13g2_tiehi
XFILLER_11_939 VPWR VGND sg13g2_decap_8
XFILLER_22_265 VPWR VGND sg13g2_decap_8
XFILLER_23_788 VPWR VGND sg13g2_decap_8
XFILLER_13_57 VPWR VGND sg13g2_decap_8
XFILLER_2_637 VPWR VGND sg13g2_decap_8
XFILLER_49_107 VPWR VGND sg13g2_decap_8
XFILLER_38_21 VPWR VGND sg13g2_decap_8
XFILLER_18_516 VPWR VGND sg13g2_decap_8
XFILLER_46_869 VPWR VGND sg13g2_decap_8
XFILLER_45_379 VPWR VGND sg13g2_decap_8
XFILLER_33_508 VPWR VGND sg13g2_decap_8
XFILLER_13_210 VPWR VGND sg13g2_decap_8
XFILLER_14_755 VPWR VGND sg13g2_decap_8
XFILLER_41_596 VPWR VGND sg13g2_fill_2
XFILLER_5_431 VPWR VGND sg13g2_fill_1
XFILLER_5_420 VPWR VGND sg13g2_decap_8
XFILLER_6_965 VPWR VGND sg13g2_decap_8
XFILLER_5_464 VPWR VGND sg13g2_decap_8
XFILLER_48_7 VPWR VGND sg13g2_decap_8
XFILLER_23_1023 VPWR VGND sg13g2_decap_4
XFILLER_49_685 VPWR VGND sg13g2_decap_8
XFILLER_37_825 VPWR VGND sg13g2_fill_2
XFILLER_37_836 VPWR VGND sg13g2_fill_1
XFILLER_45_891 VPWR VGND sg13g2_decap_8
X_2804_ _1083_ VPWR _1142_ VGND _1084_ _1085_ sg13g2_o21ai_1
XFILLER_32_596 VPWR VGND sg13g2_decap_8
XFILLER_9_770 VPWR VGND sg13g2_decap_8
X_2735_ _1054_ _1068_ _0897_ _1075_ VPWR VGND _1074_ sg13g2_nand4_1
X_2666_ _1006_ _0976_ _1004_ VPWR VGND sg13g2_xnor2_1
X_1617_ _1301_ _0968_ _1299_ VPWR VGND sg13g2_xnor2_1
X_2597_ net405 VPWR _0943_ VGND net416 net314 sg13g2_o21ai_1
XFILLER_8_1028 VPWR VGND sg13g2_fill_1
X_1548_ _1023_ _1232_ _1233_ VPWR VGND sg13g2_nor2_1
XFILLER_27_302 VPWR VGND sg13g2_fill_2
XFILLER_28_825 VPWR VGND sg13g2_fill_1
XFILLER_15_508 VPWR VGND sg13g2_decap_8
XFILLER_27_357 VPWR VGND sg13g2_decap_4
XFILLER_15_519 VPWR VGND sg13g2_fill_2
XFILLER_42_338 VPWR VGND sg13g2_decap_8
XFILLER_23_541 VPWR VGND sg13g2_fill_1
XFILLER_24_34 VPWR VGND sg13g2_decap_8
XFILLER_11_736 VPWR VGND sg13g2_decap_8
XFILLER_10_246 VPWR VGND sg13g2_decap_8
XFILLER_40_77 VPWR VGND sg13g2_decap_8
XFILLER_3_935 VPWR VGND sg13g2_decap_8
XFILLER_46_1023 VPWR VGND sg13g2_decap_4
XFILLER_2_434 VPWR VGND sg13g2_decap_8
XFILLER_49_42 VPWR VGND sg13g2_decap_8
XFILLER_49_86 VPWR VGND sg13g2_decap_8
XFILLER_19_825 VPWR VGND sg13g2_fill_2
XFILLER_46_644 VPWR VGND sg13g2_decap_8
XFILLER_1_49 VPWR VGND sg13g2_decap_8
XFILLER_33_305 VPWR VGND sg13g2_decap_8
XFILLER_14_541 VPWR VGND sg13g2_fill_1
XFILLER_42_872 VPWR VGND sg13g2_decap_8
XFILLER_14_552 VPWR VGND sg13g2_fill_1
XFILLER_6_762 VPWR VGND sg13g2_decap_8
X_2520_ falutop.i2c_inst.data_in\[9\] falutop.data_in\[9\] net319 _0037_ VPWR VGND
+ sg13g2_mux2_1
X_2451_ VPWR _0015_ net221 VGND sg13g2_inv_1
XFILLER_5_272 VPWR VGND sg13g2_decap_8
X_2382_ _0733_ net385 _0795_ VPWR VGND sg13g2_nor2_1
XFILLER_49_460 VPWR VGND sg13g2_decap_8
XFILLER_18_891 VPWR VGND sg13g2_decap_8
XFILLER_33_861 VPWR VGND sg13g2_decap_8
XFILLER_33_883 VPWR VGND sg13g2_decap_8
XFILLER_32_371 VPWR VGND sg13g2_fill_2
XFILLER_20_544 VPWR VGND sg13g2_decap_8
XFILLER_20_566 VPWR VGND sg13g2_decap_8
X_2985__93 VPWR VGND net93 sg13g2_tiehi
XFILLER_20_577 VPWR VGND sg13g2_fill_2
X_2718_ _1058_ _1023_ _1057_ VPWR VGND sg13g2_nand2_1
X_2649_ _0985_ _0987_ _0989_ VPWR VGND sg13g2_nor2_2
XFILLER_19_12 VPWR VGND sg13g2_decap_8
XFILLER_47_408 VPWR VGND sg13g2_fill_1
XFILLER_19_45 VPWR VGND sg13g2_decap_4
XFILLER_28_633 VPWR VGND sg13g2_fill_2
XFILLER_43_625 VPWR VGND sg13g2_decap_4
XFILLER_35_33 VPWR VGND sg13g2_fill_2
XFILLER_42_113 VPWR VGND sg13g2_fill_1
XFILLER_27_187 VPWR VGND sg13g2_decap_8
XFILLER_23_360 VPWR VGND sg13g2_decap_8
XFILLER_23_382 VPWR VGND sg13g2_decap_8
XFILLER_7_548 VPWR VGND sg13g2_decap_8
XFILLER_3_732 VPWR VGND sg13g2_decap_8
XFILLER_2_297 VPWR VGND sg13g2_decap_8
XFILLER_47_931 VPWR VGND sg13g2_decap_8
XFILLER_19_633 VPWR VGND sg13g2_fill_1
XFILLER_46_430 VPWR VGND sg13g2_decap_8
XFILLER_18_110 VPWR VGND sg13g2_decap_8
XFILLER_19_644 VPWR VGND sg13g2_fill_2
XFILLER_19_677 VPWR VGND sg13g2_fill_2
XFILLER_18_187 VPWR VGND sg13g2_decap_8
XFILLER_34_669 VPWR VGND sg13g2_decap_8
XFILLER_33_157 VPWR VGND sg13g2_fill_2
X_1951_ _0428_ _0425_ _0427_ VPWR VGND sg13g2_nand2_1
XFILLER_30_831 VPWR VGND sg13g2_decap_4
X_1882_ VGND VPWR _0748_ net280 _0361_ _0995_ sg13g2_a21oi_1
XFILLER_30_853 VPWR VGND sg13g2_decap_8
X_2503_ _0895_ net402 _0026_ VPWR VGND sg13g2_nor2b_1
X_2434_ _0841_ net283 _0840_ VPWR VGND sg13g2_nand2_1
XFILLER_37_0 VPWR VGND sg13g2_decap_8
X_2365_ VGND VPWR net288 _0781_ _0001_ _0782_ sg13g2_a21oi_1
X_2296_ VGND VPWR net389 _0719_ _0141_ _0720_ sg13g2_a21oi_1
XFILLER_38_953 VPWR VGND sg13g2_decap_8
XFILLER_37_430 VPWR VGND sg13g2_decap_8
XFILLER_2_92 VPWR VGND sg13g2_decap_8
XFILLER_25_658 VPWR VGND sg13g2_decap_8
XFILLER_36_1000 VPWR VGND sg13g2_decap_8
XFILLER_24_168 VPWR VGND sg13g2_fill_1
XFILLER_40_639 VPWR VGND sg13g2_decap_8
XFILLER_21_820 VPWR VGND sg13g2_decap_8
XFILLER_20_374 VPWR VGND sg13g2_decap_8
XFILLER_21_897 VPWR VGND sg13g2_decap_8
XFILLER_43_1004 VPWR VGND sg13g2_decap_8
XFILLER_48_717 VPWR VGND sg13g2_decap_8
XFILLER_0_757 VPWR VGND sg13g2_decap_8
XFILLER_46_21 VPWR VGND sg13g2_decap_8
XFILLER_46_54 VPWR VGND sg13g2_decap_8
XFILLER_29_986 VPWR VGND sg13g2_decap_8
XFILLER_44_956 VPWR VGND sg13g2_decap_8
XFILLER_15_113 VPWR VGND sg13g2_decap_4
XFILLER_15_124 VPWR VGND sg13g2_decap_8
XFILLER_16_647 VPWR VGND sg13g2_decap_8
XFILLER_43_466 VPWR VGND sg13g2_fill_1
XFILLER_8_802 VPWR VGND sg13g2_decap_8
XFILLER_12_842 VPWR VGND sg13g2_decap_8
XFILLER_8_879 VPWR VGND sg13g2_decap_8
XFILLER_7_345 VPWR VGND sg13g2_decap_4
XFILLER_7_334 VPWR VGND sg13g2_fill_1
XFILLER_39_717 VPWR VGND sg13g2_decap_8
XFILLER_38_216 VPWR VGND sg13g2_fill_1
X_2150_ VGND VPWR net317 _0621_ _0622_ _0898_ sg13g2_a21oi_1
X_2081_ _0555_ _0509_ _0554_ VPWR VGND sg13g2_nand2_1
XFILLER_38_238 VPWR VGND sg13g2_decap_8
XFILLER_46_260 VPWR VGND sg13g2_decap_8
XFILLER_19_474 VPWR VGND sg13g2_decap_8
XFILLER_35_934 VPWR VGND sg13g2_decap_8
XFILLER_22_617 VPWR VGND sg13g2_fill_2
X_2983_ net117 VGND VPWR _0140_ falutop.i2c_inst.data_in\[12\] net393 sg13g2_dfrbpq_1
XFILLER_34_488 VPWR VGND sg13g2_decap_8
XFILLER_30_650 VPWR VGND sg13g2_fill_2
X_1934_ net407 VPWR _0412_ VGND net257 net304 sg13g2_o21ai_1
X_1865_ _0343_ _0272_ _0344_ VPWR VGND sg13g2_xor2_1
X_1796_ _0276_ _0271_ _0275_ VPWR VGND sg13g2_xnor2_1
X_2417_ _0827_ net213 net289 VPWR VGND sg13g2_nand2_1
X_2348_ _0766_ _0765_ _0767_ VPWR VGND sg13g2_nor2b_2
XFILLER_29_227 VPWR VGND sg13g2_decap_8
X_2279_ net401 VPWR _0709_ VGND falutop.i2c_inst.data_in\[8\] _0708_ sg13g2_o21ai_1
XFILLER_44_219 VPWR VGND sg13g2_fill_2
XFILLER_37_293 VPWR VGND sg13g2_decap_4
XFILLER_26_945 VPWR VGND sg13g2_decap_8
XFILLER_41_926 VPWR VGND sg13g2_decap_8
XFILLER_40_403 VPWR VGND sg13g2_fill_2
XFILLER_25_488 VPWR VGND sg13g2_fill_2
XFILLER_8_109 VPWR VGND sg13g2_decap_8
XFILLER_5_849 VPWR VGND sg13g2_decap_8
X_2935__108 VPWR VGND net108 sg13g2_tiehi
XFILLER_0_554 VPWR VGND sg13g2_decap_8
XFILLER_48_503 VPWR VGND sg13g2_fill_1
XFILLER_36_709 VPWR VGND sg13g2_decap_4
XFILLER_17_912 VPWR VGND sg13g2_decap_8
XFILLER_44_753 VPWR VGND sg13g2_decap_8
XFILLER_43_252 VPWR VGND sg13g2_decap_8
XFILLER_17_989 VPWR VGND sg13g2_decap_8
XFILLER_32_904 VPWR VGND sg13g2_decap_8
XFILLER_31_458 VPWR VGND sg13g2_fill_2
XFILLER_12_694 VPWR VGND sg13g2_decap_8
XFILLER_8_676 VPWR VGND sg13g2_decap_8
X_1650_ _1331_ _1332_ _1333_ VPWR VGND sg13g2_nor2_1
Xhold109 falutop.div_inst.rem\[2\] VPWR VGND net416 sg13g2_dlygate4sd3_1
X_1581_ _1264_ VPWR _1265_ VGND net342 net280 sg13g2_o21ai_1
XFILLER_4_860 VPWR VGND sg13g2_decap_8
X_2202_ _0652_ falutop.data_in\[2\] _0653_ VPWR VGND sg13g2_xor2_1
X_2133_ _0606_ _0359_ _0605_ VPWR VGND sg13g2_nand2_1
XFILLER_19_271 VPWR VGND sg13g2_decap_4
X_2064_ _0538_ VPWR _0539_ VGND _1141_ _0534_ sg13g2_o21ai_1
XFILLER_23_904 VPWR VGND sg13g2_decap_8
XFILLER_22_469 VPWR VGND sg13g2_fill_2
X_2966_ net147 VGND VPWR _0123_ falutop.div_inst.a\[3\] clknet_4_5_0_clk sg13g2_dfrbpq_1
X_1917_ _0393_ _0367_ _0395_ VPWR VGND sg13g2_xor2_1
X_2897_ net28 VGND VPWR _0054_ falutop.div_inst.b1\[0\] clknet_4_1_0_clk sg13g2_dfrbpq_1
XFILLER_30_491 VPWR VGND sg13g2_fill_1
X_1848_ VGND VPWR net332 net370 _0327_ _0261_ sg13g2_a21oi_1
XFILLER_2_819 VPWR VGND sg13g2_decap_8
X_1779_ VGND VPWR _0203_ _0216_ _0259_ _0215_ sg13g2_a21oi_1
XFILLER_38_580 VPWR VGND sg13g2_decap_8
XFILLER_26_720 VPWR VGND sg13g2_fill_1
XFILLER_14_915 VPWR VGND sg13g2_decap_8
XFILLER_25_241 VPWR VGND sg13g2_decap_4
XFILLER_26_753 VPWR VGND sg13g2_fill_2
XFILLER_25_274 VPWR VGND sg13g2_decap_8
XFILLER_41_745 VPWR VGND sg13g2_decap_8
XFILLER_13_447 VPWR VGND sg13g2_decap_8
XFILLER_13_458 VPWR VGND sg13g2_decap_4
XFILLER_43_99 VPWR VGND sg13g2_decap_8
XFILLER_43_77 VPWR VGND sg13g2_decap_8
XFILLER_22_970 VPWR VGND sg13g2_decap_8
XFILLER_40_288 VPWR VGND sg13g2_decap_8
XFILLER_21_491 VPWR VGND sg13g2_decap_8
XFILLER_5_646 VPWR VGND sg13g2_decap_8
XFILLER_49_1021 VPWR VGND sg13g2_decap_8
XFILLER_4_178 VPWR VGND sg13g2_decap_8
XFILLER_0_351 VPWR VGND sg13g2_decap_8
XFILLER_1_896 VPWR VGND sg13g2_decap_8
XFILLER_49_867 VPWR VGND sg13g2_decap_8
XFILLER_48_344 VPWR VGND sg13g2_decap_4
XFILLER_1_1001 VPWR VGND sg13g2_decap_8
XFILLER_44_572 VPWR VGND sg13g2_decap_8
X_2820_ VGND VPWR _1154_ _1155_ _1158_ _1148_ sg13g2_a21oi_1
XFILLER_20_929 VPWR VGND sg13g2_decap_8
XFILLER_31_277 VPWR VGND sg13g2_decap_4
XFILLER_32_789 VPWR VGND sg13g2_decap_4
XFILLER_9_952 VPWR VGND sg13g2_decap_8
XFILLER_12_491 VPWR VGND sg13g2_fill_2
X_2751_ _1090_ net351 net284 VPWR VGND sg13g2_nand2_1
XFILLER_8_473 VPWR VGND sg13g2_decap_8
X_2682_ VGND VPWR _1018_ _1022_ _1021_ _1019_ sg13g2_a21oi_2
X_1702_ VPWR VGND _1115_ _0183_ _0178_ _0994_ _0184_ _0174_ sg13g2_a221oi_1
X_1633_ VGND VPWR _1298_ _1314_ _1317_ net292 sg13g2_a21oi_1
X_1564_ _1238_ _1246_ _1248_ _1249_ VPWR VGND sg13g2_or3_1
Xfanout408 net409 net408 VPWR VGND sg13g2_buf_8
X_1495_ _0968_ VPWR _1181_ VGND _1071_ _1072_ sg13g2_o21ai_1
X_2116_ _0589_ _0510_ _0587_ VPWR VGND sg13g2_xnor2_1
XFILLER_39_399 VPWR VGND sg13g2_decap_8
X_2047_ _0520_ _0505_ _0522_ VPWR VGND sg13g2_xor2_1
X_2861__76 VPWR VGND net76 sg13g2_tiehi
XFILLER_23_734 VPWR VGND sg13g2_fill_1
XFILLER_35_594 VPWR VGND sg13g2_decap_4
XFILLER_11_918 VPWR VGND sg13g2_decap_8
X_2949_ net65 VGND VPWR _0106_ falutop.alu_data_in\[9\] clknet_4_10_0_clk sg13g2_dfrbpq_2
XFILLER_2_616 VPWR VGND sg13g2_decap_8
XFILLER_1_126 VPWR VGND sg13g2_decap_4
XFILLER_1_159 VPWR VGND sg13g2_decap_8
XFILLER_46_848 VPWR VGND sg13g2_decap_8
XFILLER_45_358 VPWR VGND sg13g2_decap_8
XFILLER_45_347 VPWR VGND sg13g2_decap_4
XFILLER_14_723 VPWR VGND sg13g2_decap_8
XFILLER_41_564 VPWR VGND sg13g2_fill_1
XFILLER_41_553 VPWR VGND sg13g2_decap_8
XFILLER_14_789 VPWR VGND sg13g2_decap_8
XFILLER_6_944 VPWR VGND sg13g2_decap_8
XFILLER_10_995 VPWR VGND sg13g2_decap_8
XFILLER_5_443 VPWR VGND sg13g2_decap_8
XFILLER_1_693 VPWR VGND sg13g2_decap_8
XFILLER_23_1002 VPWR VGND sg13g2_decap_8
XFILLER_49_664 VPWR VGND sg13g2_decap_8
XFILLER_37_804 VPWR VGND sg13g2_decap_8
XFILLER_37_859 VPWR VGND sg13g2_decap_8
XFILLER_45_870 VPWR VGND sg13g2_decap_8
XFILLER_17_594 VPWR VGND sg13g2_decap_8
XFILLER_32_553 VPWR VGND sg13g2_decap_8
X_2803_ VPWR _1141_ net290 VGND sg13g2_inv_1
X_2734_ VPWR VGND _0999_ _1048_ _1073_ _1056_ _1074_ _1061_ sg13g2_a221oi_1
XFILLER_30_1028 VPWR VGND sg13g2_fill_1
XFILLER_8_292 VPWR VGND sg13g2_fill_1
X_2665_ _0976_ _1004_ _1005_ VPWR VGND sg13g2_nor2b_1
X_2596_ VGND VPWR _0830_ net310 _0072_ net419 sg13g2_a21oi_1
X_1616_ VGND VPWR _1300_ _1299_ _0969_ sg13g2_or2_1
X_1547_ VGND VPWR _0752_ net323 _1232_ net324 sg13g2_a21oi_1
XFILLER_39_130 VPWR VGND sg13g2_fill_2
XFILLER_39_185 VPWR VGND sg13g2_fill_2
XFILLER_28_848 VPWR VGND sg13g2_fill_1
XFILLER_27_336 VPWR VGND sg13g2_decap_8
XFILLER_43_829 VPWR VGND sg13g2_decap_8
XFILLER_42_317 VPWR VGND sg13g2_decap_8
XFILLER_36_881 VPWR VGND sg13g2_decap_8
XFILLER_11_715 VPWR VGND sg13g2_decap_8
XFILLER_23_575 VPWR VGND sg13g2_fill_1
XFILLER_10_225 VPWR VGND sg13g2_decap_8
XFILLER_40_56 VPWR VGND sg13g2_decap_8
XFILLER_3_914 VPWR VGND sg13g2_decap_8
XFILLER_2_413 VPWR VGND sg13g2_decap_8
XFILLER_49_21 VPWR VGND sg13g2_decap_8
XFILLER_46_1002 VPWR VGND sg13g2_decap_8
XFILLER_6_4 VPWR VGND sg13g2_decap_8
XFILLER_1_28 VPWR VGND sg13g2_decap_8
XFILLER_46_623 VPWR VGND sg13g2_decap_8
XFILLER_34_829 VPWR VGND sg13g2_fill_1
XFILLER_45_188 VPWR VGND sg13g2_fill_1
XFILLER_33_339 VPWR VGND sg13g2_decap_8
XFILLER_42_851 VPWR VGND sg13g2_decap_8
XFILLER_41_361 VPWR VGND sg13g2_fill_2
XFILLER_6_741 VPWR VGND sg13g2_decap_8
XFILLER_10_792 VPWR VGND sg13g2_decap_8
X_2450_ _0854_ _0852_ _0767_ _0775_ net220 VPWR VGND sg13g2_a22oi_1
XFILLER_5_251 VPWR VGND sg13g2_decap_8
X_2381_ VGND VPWR net287 _0793_ _0005_ _0794_ sg13g2_a21oi_1
XFILLER_2_980 VPWR VGND sg13g2_decap_8
XFILLER_1_490 VPWR VGND sg13g2_decap_8
XFILLER_37_634 VPWR VGND sg13g2_decap_4
XFILLER_25_807 VPWR VGND sg13g2_decap_8
XFILLER_36_133 VPWR VGND sg13g2_decap_8
XFILLER_18_870 VPWR VGND sg13g2_decap_8
XFILLER_24_317 VPWR VGND sg13g2_decap_8
XFILLER_25_829 VPWR VGND sg13g2_decap_8
XFILLER_36_166 VPWR VGND sg13g2_decap_8
X_2717_ _0751_ VPWR _1057_ VGND net326 net351 sg13g2_o21ai_1
X_2648_ _0988_ net328 net356 VPWR VGND sg13g2_nand2_1
XFILLER_0_939 VPWR VGND sg13g2_decap_8
X_2579_ net406 VPWR _0934_ VGND net230 net310 sg13g2_o21ai_1
XFILLER_19_35 VPWR VGND sg13g2_fill_1
XFILLER_28_656 VPWR VGND sg13g2_decap_4
XFILLER_43_604 VPWR VGND sg13g2_decap_8
XFILLER_27_155 VPWR VGND sg13g2_decap_8
XFILLER_35_12 VPWR VGND sg13g2_decap_8
XFILLER_43_648 VPWR VGND sg13g2_decap_8
XFILLER_15_339 VPWR VGND sg13g2_decap_8
XFILLER_24_840 VPWR VGND sg13g2_fill_1
XFILLER_30_309 VPWR VGND sg13g2_decap_8
XFILLER_11_501 VPWR VGND sg13g2_decap_8
XFILLER_24_884 VPWR VGND sg13g2_decap_8
XFILLER_7_527 VPWR VGND sg13g2_decap_8
X_2977__111 VPWR VGND net111 sg13g2_tiehi
XFILLER_3_711 VPWR VGND sg13g2_decap_8
XFILLER_3_788 VPWR VGND sg13g2_decap_8
XFILLER_2_287 VPWR VGND sg13g2_fill_1
XFILLER_47_910 VPWR VGND sg13g2_decap_8
X_2914__150 VPWR VGND net150 sg13g2_tiehi
XFILLER_20_1027 VPWR VGND sg13g2_fill_2
XFILLER_47_987 VPWR VGND sg13g2_decap_8
XFILLER_46_486 VPWR VGND sg13g2_fill_1
XFILLER_46_475 VPWR VGND sg13g2_decap_8
XFILLER_18_166 VPWR VGND sg13g2_decap_8
XFILLER_34_615 VPWR VGND sg13g2_decap_8
XFILLER_14_350 VPWR VGND sg13g2_fill_2
X_1950_ net345 net356 _0427_ VPWR VGND sg13g2_nor2b_2
XFILLER_14_361 VPWR VGND sg13g2_fill_1
XFILLER_15_884 VPWR VGND sg13g2_decap_8
XFILLER_30_810 VPWR VGND sg13g2_decap_4
X_1881_ _0303_ _0949_ _0358_ _0360_ VPWR VGND sg13g2_a21o_1
X_2502_ VGND VPWR falutop.i2c_inst.counter\[4\] _0893_ _0895_ _0894_ sg13g2_a21oi_1
X_2433_ _0840_ _0815_ _0816_ VPWR VGND sg13g2_xnor2_1
X_2364_ net193 net288 _0782_ VPWR VGND sg13g2_nor2_1
X_2295_ net401 VPWR _0720_ VGND falutop.i2c_inst.data_in\[13\] _0719_ sg13g2_o21ai_1
XFILLER_38_932 VPWR VGND sg13g2_decap_8
XFILLER_2_60 VPWR VGND sg13g2_decap_8
XFILLER_2_71 VPWR VGND sg13g2_decap_8
XFILLER_25_637 VPWR VGND sg13g2_decap_8
XFILLER_20_331 VPWR VGND sg13g2_fill_1
XFILLER_32_191 VPWR VGND sg13g2_fill_1
XFILLER_21_876 VPWR VGND sg13g2_decap_8
XFILLER_0_736 VPWR VGND sg13g2_decap_8
XFILLER_29_965 VPWR VGND sg13g2_decap_8
XFILLER_16_604 VPWR VGND sg13g2_decap_8
XFILLER_46_99 VPWR VGND sg13g2_decap_8
XFILLER_44_935 VPWR VGND sg13g2_decap_8
XFILLER_16_626 VPWR VGND sg13g2_decap_8
XFILLER_31_618 VPWR VGND sg13g2_decap_8
XFILLER_12_821 VPWR VGND sg13g2_decap_8
XFILLER_11_320 VPWR VGND sg13g2_decap_8
XFILLER_23_180 VPWR VGND sg13g2_decap_8
XFILLER_12_898 VPWR VGND sg13g2_decap_8
XFILLER_8_858 VPWR VGND sg13g2_decap_8
XFILLER_7_379 VPWR VGND sg13g2_decap_8
XFILLER_3_585 VPWR VGND sg13g2_decap_8
Xclkbuf_4_9_0_clk clknet_0_clk clknet_4_9_0_clk VPWR VGND sg13g2_buf_8
XFILLER_38_228 VPWR VGND sg13g2_decap_4
X_2080_ _0554_ _0548_ _0553_ VPWR VGND sg13g2_xnor2_1
XFILLER_4_1021 VPWR VGND sg13g2_decap_8
XFILLER_19_442 VPWR VGND sg13g2_fill_1
XFILLER_47_784 VPWR VGND sg13g2_decap_8
XFILLER_35_913 VPWR VGND sg13g2_decap_8
XFILLER_46_294 VPWR VGND sg13g2_decap_8
XFILLER_34_434 VPWR VGND sg13g2_decap_8
XFILLER_43_990 VPWR VGND sg13g2_decap_8
X_2982_ net125 VGND VPWR _0139_ falutop.i2c_inst.data_in\[11\] net392 sg13g2_dfrbpq_1
XFILLER_21_139 VPWR VGND sg13g2_fill_2
X_1933_ VGND VPWR _0409_ _0410_ _0411_ _0898_ sg13g2_a21oi_1
X_2955__31 VPWR VGND net31 sg13g2_tiehi
X_1864_ _0343_ _0340_ _0341_ VPWR VGND sg13g2_xnor2_1
X_1795_ VGND VPWR _1328_ _0272_ _0275_ _0274_ sg13g2_a21oi_1
XFILLER_7_891 VPWR VGND sg13g2_decap_8
X_2416_ _0801_ VPWR _0008_ VGND _0768_ _0826_ sg13g2_o21ai_1
X_2347_ _0766_ falutop.div_inst.busy VPWR VGND net388 sg13g2_nand2b_2
XFILLER_29_206 VPWR VGND sg13g2_decap_8
X_2278_ _0877_ _0707_ _0708_ VPWR VGND sg13g2_nor2_1
XFILLER_38_784 VPWR VGND sg13g2_decap_4
XFILLER_38_762 VPWR VGND sg13g2_fill_2
XFILLER_26_924 VPWR VGND sg13g2_decap_8
XFILLER_41_905 VPWR VGND sg13g2_decap_8
XFILLER_13_607 VPWR VGND sg13g2_fill_1
XFILLER_25_445 VPWR VGND sg13g2_decap_8
XFILLER_21_640 VPWR VGND sg13g2_fill_2
XFILLER_32_35 VPWR VGND sg13g2_decap_8
XFILLER_21_695 VPWR VGND sg13g2_decap_8
XFILLER_5_828 VPWR VGND sg13g2_decap_8
XFILLER_0_533 VPWR VGND sg13g2_decap_8
XFILLER_29_740 VPWR VGND sg13g2_decap_8
XFILLER_29_762 VPWR VGND sg13g2_decap_8
XFILLER_35_209 VPWR VGND sg13g2_decap_8
XFILLER_16_401 VPWR VGND sg13g2_decap_8
XFILLER_16_423 VPWR VGND sg13g2_decap_8
XFILLER_43_231 VPWR VGND sg13g2_decap_8
XFILLER_16_434 VPWR VGND sg13g2_fill_2
XFILLER_17_968 VPWR VGND sg13g2_decap_8
XFILLER_16_489 VPWR VGND sg13g2_fill_2
XFILLER_31_415 VPWR VGND sg13g2_decap_4
XFILLER_31_437 VPWR VGND sg13g2_decap_8
XFILLER_40_982 VPWR VGND sg13g2_decap_8
XFILLER_12_673 VPWR VGND sg13g2_decap_8
XFILLER_8_655 VPWR VGND sg13g2_decap_8
XFILLER_11_172 VPWR VGND sg13g2_decap_8
XFILLER_7_198 VPWR VGND sg13g2_decap_4
X_1580_ VGND VPWR _0762_ net278 _1264_ net285 sg13g2_a21oi_1
XFILLER_26_1022 VPWR VGND sg13g2_decap_8
XFILLER_39_504 VPWR VGND sg13g2_decap_8
X_2201_ net384 VPWR _0652_ VGND falutop.data_in\[0\] falutop.data_in\[1\] sg13g2_o21ai_1
XFILLER_39_559 VPWR VGND sg13g2_fill_2
X_2132_ _0604_ VPWR _0605_ VGND net358 net279 sg13g2_o21ai_1
XFILLER_26_209 VPWR VGND sg13g2_decap_4
X_2063_ net304 _0537_ _0538_ VPWR VGND sg13g2_and2_1
XFILLER_35_710 VPWR VGND sg13g2_fill_1
XFILLER_34_242 VPWR VGND sg13g2_fill_1
XFILLER_22_415 VPWR VGND sg13g2_decap_8
XFILLER_22_448 VPWR VGND sg13g2_decap_8
X_2965_ net149 VGND VPWR _0122_ falutop.div_inst.a\[2\] clknet_4_5_0_clk sg13g2_dfrbpq_1
X_2896_ net30 VGND VPWR net199 falutop.div_inst.i\[2\] clknet_4_10_0_clk sg13g2_dfrbpq_1
X_1916_ _0394_ _0367_ _0393_ VPWR VGND sg13g2_nand2b_1
XFILLER_8_92 VPWR VGND sg13g2_decap_4
X_1847_ _0273_ VPWR _0326_ VGND _0271_ _0274_ sg13g2_o21ai_1
X_1778_ _0201_ VPWR _0258_ VGND _1346_ _0202_ sg13g2_o21ai_1
XFILLER_26_732 VPWR VGND sg13g2_decap_8
XFILLER_41_724 VPWR VGND sg13g2_decap_4
XFILLER_13_404 VPWR VGND sg13g2_decap_8
XFILLER_25_253 VPWR VGND sg13g2_decap_8
XFILLER_25_264 VPWR VGND sg13g2_fill_2
XFILLER_26_776 VPWR VGND sg13g2_decap_4
XFILLER_43_56 VPWR VGND sg13g2_decap_8
XFILLER_41_768 VPWR VGND sg13g2_decap_8
XFILLER_40_267 VPWR VGND sg13g2_decap_8
XFILLER_21_470 VPWR VGND sg13g2_decap_8
XFILLER_49_1000 VPWR VGND sg13g2_decap_8
XFILLER_5_625 VPWR VGND sg13g2_decap_8
XFILLER_4_135 VPWR VGND sg13g2_decap_8
XFILLER_0_330 VPWR VGND sg13g2_decap_8
XFILLER_48_301 VPWR VGND sg13g2_fill_1
XFILLER_1_875 VPWR VGND sg13g2_decap_8
XFILLER_49_846 VPWR VGND sg13g2_decap_8
XFILLER_17_732 VPWR VGND sg13g2_fill_2
XFILLER_17_765 VPWR VGND sg13g2_decap_8
XFILLER_32_702 VPWR VGND sg13g2_fill_2
XFILLER_32_724 VPWR VGND sg13g2_decap_4
XFILLER_20_908 VPWR VGND sg13g2_decap_8
XFILLER_32_757 VPWR VGND sg13g2_decap_8
XFILLER_9_931 VPWR VGND sg13g2_decap_8
XFILLER_13_982 VPWR VGND sg13g2_decap_8
X_2750_ net351 net372 net279 _1089_ VPWR VGND sg13g2_mux2_1
XFILLER_8_452 VPWR VGND sg13g2_decap_8
XFILLER_8_441 VPWR VGND sg13g2_decap_8
X_2681_ _1021_ net325 _0751_ VPWR VGND sg13g2_nand2_1
X_1701_ _0180_ _0181_ _0176_ _0183_ VPWR VGND _0182_ sg13g2_nand4_1
X_1632_ VGND VPWR _1316_ _1314_ _1298_ sg13g2_or2_1
X_1563_ VGND VPWR _1244_ _1245_ _1248_ _1239_ sg13g2_a21oi_1
Xfanout409 net410 net409 VPWR VGND sg13g2_buf_8
XFILLER_39_345 VPWR VGND sg13g2_fill_1
X_2115_ _0509_ _0587_ _0588_ VPWR VGND sg13g2_nor2_1
XFILLER_39_378 VPWR VGND sg13g2_decap_8
X_2046_ VPWR _0521_ _0520_ VGND sg13g2_inv_1
XFILLER_22_245 VPWR VGND sg13g2_decap_8
XFILLER_22_256 VPWR VGND sg13g2_fill_2
XFILLER_10_429 VPWR VGND sg13g2_decap_8
X_2948_ net67 VGND VPWR _0105_ falutop.alu_data_in\[8\] clknet_4_11_0_clk sg13g2_dfrbpq_1
X_2879_ net51 VGND VPWR _0036_ falutop.data_in\[8\] net392 sg13g2_dfrbpq_2
XFILLER_38_78 VPWR VGND sg13g2_decap_8
XFILLER_38_56 VPWR VGND sg13g2_decap_4
XFILLER_46_827 VPWR VGND sg13g2_decap_8
XFILLER_45_326 VPWR VGND sg13g2_decap_8
XFILLER_26_562 VPWR VGND sg13g2_fill_1
XFILLER_13_245 VPWR VGND sg13g2_decap_4
XFILLER_6_923 VPWR VGND sg13g2_decap_8
XFILLER_10_974 VPWR VGND sg13g2_decap_8
XFILLER_5_499 VPWR VGND sg13g2_decap_8
XFILLER_49_643 VPWR VGND sg13g2_decap_8
XFILLER_1_672 VPWR VGND sg13g2_decap_8
XFILLER_48_131 VPWR VGND sg13g2_fill_2
X_2987__113 VPWR VGND net113 sg13g2_tiehi
XFILLER_0_193 VPWR VGND sg13g2_decap_8
XFILLER_37_827 VPWR VGND sg13g2_fill_1
XFILLER_36_304 VPWR VGND sg13g2_decap_8
XFILLER_17_540 VPWR VGND sg13g2_decap_8
XFILLER_17_562 VPWR VGND sg13g2_decap_8
XFILLER_20_705 VPWR VGND sg13g2_decap_8
X_2924__130 VPWR VGND net130 sg13g2_tiehi
X_2802_ net317 _1139_ _1140_ VPWR VGND sg13g2_nor2_1
X_2733_ _1069_ _1071_ _1072_ _1073_ VPWR VGND sg13g2_or3_1
XFILLER_30_1007 VPWR VGND sg13g2_decap_8
X_2664_ _1003_ _0961_ _1004_ VPWR VGND sg13g2_xor2_1
X_2595_ net406 VPWR _0942_ VGND net418 net314 sg13g2_o21ai_1
X_1615_ _1299_ net343 net373 VPWR VGND sg13g2_nand2_1
X_1546_ _1231_ _1022_ _1094_ VPWR VGND sg13g2_nand2_1
XFILLER_8_1019 VPWR VGND sg13g2_decap_8
XFILLER_5_93 VPWR VGND sg13g2_decap_8
XFILLER_43_808 VPWR VGND sg13g2_decap_8
X_2029_ _0504_ _0503_ net327 VPWR VGND sg13g2_nand2b_1
XFILLER_23_554 VPWR VGND sg13g2_decap_8
XFILLER_10_215 VPWR VGND sg13g2_decap_4
XFILLER_24_69 VPWR VGND sg13g2_decap_8
XFILLER_7_709 VPWR VGND sg13g2_decap_8
XFILLER_40_35 VPWR VGND sg13g2_decap_8
X_2899__173 VPWR VGND net173 sg13g2_tiehi
XFILLER_2_469 VPWR VGND sg13g2_decap_8
XFILLER_46_602 VPWR VGND sg13g2_decap_8
XFILLER_18_326 VPWR VGND sg13g2_decap_8
XFILLER_19_827 VPWR VGND sg13g2_fill_1
XFILLER_19_849 VPWR VGND sg13g2_decap_8
XFILLER_34_808 VPWR VGND sg13g2_decap_8
XFILLER_46_679 VPWR VGND sg13g2_decap_8
XFILLER_45_167 VPWR VGND sg13g2_decap_8
XFILLER_27_882 VPWR VGND sg13g2_decap_8
XFILLER_42_830 VPWR VGND sg13g2_decap_8
XFILLER_41_340 VPWR VGND sg13g2_decap_8
XFILLER_14_598 VPWR VGND sg13g2_decap_8
XFILLER_6_720 VPWR VGND sg13g2_decap_8
XFILLER_10_771 VPWR VGND sg13g2_decap_8
XFILLER_6_797 VPWR VGND sg13g2_decap_8
X_2380_ net196 net287 _0794_ VPWR VGND sg13g2_nor2_1
XFILLER_49_484 VPWR VGND sg13g2_decap_8
XFILLER_36_112 VPWR VGND sg13g2_decap_8
XFILLER_37_679 VPWR VGND sg13g2_decap_8
XFILLER_32_351 VPWR VGND sg13g2_fill_2
X_2716_ net378 _1055_ _1056_ VPWR VGND sg13g2_nor2_1
X_2647_ _0755_ _0760_ _0987_ VPWR VGND sg13g2_nor2_1
XFILLER_0_918 VPWR VGND sg13g2_decap_8
X_2578_ _0932_ _0933_ _0063_ VPWR VGND sg13g2_nor2_1
X_1529_ VGND VPWR _1168_ _1212_ _1214_ _1213_ sg13g2_a21oi_1
XFILLER_19_58 VPWR VGND sg13g2_fill_1
XFILLER_27_112 VPWR VGND sg13g2_decap_8
XFILLER_27_134 VPWR VGND sg13g2_decap_8
XFILLER_28_635 VPWR VGND sg13g2_fill_1
XFILLER_28_679 VPWR VGND sg13g2_decap_8
XFILLER_15_318 VPWR VGND sg13g2_fill_2
XFILLER_7_506 VPWR VGND sg13g2_decap_8
XFILLER_13_1024 VPWR VGND sg13g2_decap_4
XFILLER_3_767 VPWR VGND sg13g2_decap_8
XFILLER_19_613 VPWR VGND sg13g2_decap_4
XFILLER_47_966 VPWR VGND sg13g2_decap_8
XFILLER_19_646 VPWR VGND sg13g2_fill_1
XFILLER_20_1006 VPWR VGND sg13g2_decap_8
XFILLER_46_454 VPWR VGND sg13g2_decap_8
XFILLER_18_145 VPWR VGND sg13g2_decap_8
XFILLER_19_679 VPWR VGND sg13g2_fill_1
XFILLER_34_649 VPWR VGND sg13g2_fill_2
XFILLER_15_863 VPWR VGND sg13g2_decap_8
XFILLER_33_137 VPWR VGND sg13g2_decap_8
XFILLER_42_682 VPWR VGND sg13g2_fill_1
XFILLER_41_181 VPWR VGND sg13g2_decap_8
XFILLER_14_384 VPWR VGND sg13g2_decap_4
X_1880_ VGND VPWR _0358_ _0359_ _0303_ _0949_ sg13g2_a21oi_2
XFILLER_30_888 VPWR VGND sg13g2_decap_8
X_2501_ falutop.i2c_inst.state\[1\] falutop.i2c_inst.state\[0\] _0764_ net2 _0894_
+ VPWR VGND sg13g2_nor4_1
XFILLER_6_594 VPWR VGND sg13g2_decap_8
X_2432_ _0839_ net205 net289 VPWR VGND sg13g2_nand2_1
X_2363_ VGND VPWR net385 falutop.div_inst.a\[1\] _0781_ _0780_ sg13g2_a21oi_1
X_2294_ _0689_ _0716_ _0719_ VPWR VGND sg13g2_nor2_1
XFILLER_38_911 VPWR VGND sg13g2_decap_8
XFILLER_49_292 VPWR VGND sg13g2_decap_8
XFILLER_38_988 VPWR VGND sg13g2_decap_8
XFILLER_25_605 VPWR VGND sg13g2_fill_2
XFILLER_24_148 VPWR VGND sg13g2_decap_8
XFILLER_33_660 VPWR VGND sg13g2_decap_8
XFILLER_21_855 VPWR VGND sg13g2_decap_4
XFILLER_32_170 VPWR VGND sg13g2_decap_8
XFILLER_21_37 VPWR VGND sg13g2_decap_8
XFILLER_0_715 VPWR VGND sg13g2_decap_8
XFILLER_47_229 VPWR VGND sg13g2_decap_8
XFILLER_29_944 VPWR VGND sg13g2_decap_8
XFILLER_44_914 VPWR VGND sg13g2_decap_8
XFILLER_28_476 VPWR VGND sg13g2_decap_8
XFILLER_43_424 VPWR VGND sg13g2_decap_8
XFILLER_28_498 VPWR VGND sg13g2_decap_8
XFILLER_12_800 VPWR VGND sg13g2_decap_8
XFILLER_24_682 VPWR VGND sg13g2_decap_8
XFILLER_8_837 VPWR VGND sg13g2_decap_8
XFILLER_12_877 VPWR VGND sg13g2_decap_8
XFILLER_11_376 VPWR VGND sg13g2_fill_2
XFILLER_7_358 VPWR VGND sg13g2_decap_8
XFILLER_3_564 VPWR VGND sg13g2_decap_8
XFILLER_11_81 VPWR VGND sg13g2_decap_8
XFILLER_4_1000 VPWR VGND sg13g2_decap_8
XFILLER_47_763 VPWR VGND sg13g2_decap_8
XFILLER_34_413 VPWR VGND sg13g2_decap_8
XFILLER_22_608 VPWR VGND sg13g2_decap_4
XFILLER_35_969 VPWR VGND sg13g2_decap_8
XFILLER_21_118 VPWR VGND sg13g2_decap_8
X_2981_ net133 VGND VPWR _0138_ falutop.i2c_inst.data_in\[10\] net392 sg13g2_dfrbpq_1
X_1932_ net315 _0408_ _0410_ VPWR VGND sg13g2_nor2_1
X_1863_ _0340_ _0341_ _0342_ VPWR VGND sg13g2_nor2b_1
XFILLER_7_870 VPWR VGND sg13g2_decap_8
X_1794_ _0274_ net360 net347 net359 net349 VPWR VGND sg13g2_a22oi_1
XFILLER_42_0 VPWR VGND sg13g2_fill_2
X_2415_ _0825_ net235 _0826_ VPWR VGND sg13g2_xor2_1
X_2346_ falutop.div_inst.i\[1\] net216 net198 _0765_ VPWR VGND sg13g2_nand3_1
X_2277_ _0707_ _0741_ _0706_ VPWR VGND sg13g2_nand2_2
XFILLER_37_240 VPWR VGND sg13g2_decap_4
XFILLER_26_903 VPWR VGND sg13g2_decap_8
XFILLER_25_413 VPWR VGND sg13g2_fill_1
XFILLER_25_424 VPWR VGND sg13g2_decap_8
XFILLER_16_37 VPWR VGND sg13g2_decap_4
XFILLER_16_48 VPWR VGND sg13g2_fill_2
XFILLER_13_619 VPWR VGND sg13g2_fill_2
XFILLER_40_449 VPWR VGND sg13g2_fill_2
XFILLER_40_438 VPWR VGND sg13g2_decap_8
XFILLER_12_129 VPWR VGND sg13g2_decap_8
XFILLER_21_663 VPWR VGND sg13g2_fill_1
XFILLER_32_14 VPWR VGND sg13g2_decap_8
XFILLER_20_173 VPWR VGND sg13g2_decap_4
XFILLER_5_807 VPWR VGND sg13g2_decap_8
XFILLER_10_1016 VPWR VGND sg13g2_decap_8
XFILLER_4_328 VPWR VGND sg13g2_fill_2
XFILLER_10_1027 VPWR VGND sg13g2_fill_2
XFILLER_0_512 VPWR VGND sg13g2_decap_8
XFILLER_0_589 VPWR VGND sg13g2_decap_8
XFILLER_16_413 VPWR VGND sg13g2_decap_4
XFILLER_17_947 VPWR VGND sg13g2_decap_8
XFILLER_28_251 VPWR VGND sg13g2_fill_2
XFILLER_16_457 VPWR VGND sg13g2_decap_8
XFILLER_44_788 VPWR VGND sg13g2_decap_8
XFILLER_25_980 VPWR VGND sg13g2_decap_8
XFILLER_32_939 VPWR VGND sg13g2_decap_8
XFILLER_43_298 VPWR VGND sg13g2_fill_2
XFILLER_43_287 VPWR VGND sg13g2_decap_8
XFILLER_40_961 VPWR VGND sg13g2_decap_8
XFILLER_12_652 VPWR VGND sg13g2_decap_8
XFILLER_8_634 VPWR VGND sg13g2_decap_8
XFILLER_7_133 VPWR VGND sg13g2_decap_4
XFILLER_7_177 VPWR VGND sg13g2_decap_8
XFILLER_22_91 VPWR VGND sg13g2_decap_8
XFILLER_4_895 VPWR VGND sg13g2_decap_8
X_2200_ net239 net302 _0651_ VPWR VGND sg13g2_nor2_1
XFILLER_26_1001 VPWR VGND sg13g2_decap_8
XFILLER_14_4 VPWR VGND sg13g2_decap_8
X_2131_ VGND VPWR net324 net278 _0604_ net285 sg13g2_a21oi_1
XFILLER_19_240 VPWR VGND sg13g2_fill_2
X_2062_ _0535_ _0536_ net317 _0537_ VPWR VGND sg13g2_nand3_1
XFILLER_19_262 VPWR VGND sg13g2_decap_4
XFILLER_19_295 VPWR VGND sg13g2_decap_8
XFILLER_34_221 VPWR VGND sg13g2_decap_8
XFILLER_35_744 VPWR VGND sg13g2_decap_8
XFILLER_23_939 VPWR VGND sg13g2_decap_8
XFILLER_34_254 VPWR VGND sg13g2_decap_8
XFILLER_35_799 VPWR VGND sg13g2_decap_8
X_2964_ net151 VGND VPWR _0121_ falutop.div_inst.a\[1\] clknet_4_4_0_clk sg13g2_dfrbpq_1
X_1915_ _0391_ _0368_ _0393_ VPWR VGND sg13g2_xor2_1
XFILLER_33_1016 VPWR VGND sg13g2_decap_8
X_2895_ net32 VGND VPWR net233 falutop.div_inst.i\[1\] clknet_4_10_0_clk sg13g2_dfrbpq_1
XFILLER_30_482 VPWR VGND sg13g2_decap_8
XFILLER_31_983 VPWR VGND sg13g2_decap_8
XFILLER_33_1027 VPWR VGND sg13g2_fill_2
X_1846_ VPWR _0325_ _0324_ VGND sg13g2_inv_1
X_1777_ _0190_ _0257_ _0085_ VPWR VGND sg13g2_nor2_1
X_2934__110 VPWR VGND net110 sg13g2_tiehi
X_2329_ _0748_ net352 VPWR VGND sg13g2_inv_2
XFILLER_27_69 VPWR VGND sg13g2_decap_8
XFILLER_26_755 VPWR VGND sg13g2_fill_1
XFILLER_41_703 VPWR VGND sg13g2_decap_8
XFILLER_43_35 VPWR VGND sg13g2_decap_8
XFILLER_40_213 VPWR VGND sg13g2_fill_2
Xclkbuf_4_8_0_clk clknet_0_clk clknet_4_8_0_clk VPWR VGND sg13g2_buf_8
XFILLER_40_246 VPWR VGND sg13g2_decap_8
XFILLER_5_604 VPWR VGND sg13g2_decap_8
XFILLER_4_18 VPWR VGND sg13g2_decap_8
XFILLER_1_854 VPWR VGND sg13g2_decap_8
XFILLER_49_825 VPWR VGND sg13g2_decap_8
XFILLER_0_386 VPWR VGND sg13g2_decap_8
XFILLER_29_571 VPWR VGND sg13g2_decap_8
XFILLER_44_530 VPWR VGND sg13g2_decap_8
X_2855__86 VPWR VGND net86 sg13g2_tiehi
XFILLER_17_799 VPWR VGND sg13g2_decap_4
XFILLER_16_276 VPWR VGND sg13g2_decap_8
XFILLER_31_224 VPWR VGND sg13g2_fill_2
XFILLER_9_910 VPWR VGND sg13g2_decap_8
XFILLER_13_961 VPWR VGND sg13g2_decap_8
XFILLER_9_987 VPWR VGND sg13g2_decap_8
XFILLER_12_493 VPWR VGND sg13g2_fill_1
X_2680_ _1020_ _1017_ VPWR VGND _1019_ sg13g2_nand2b_2
X_1700_ _0182_ _1126_ _0955_ _1071_ _0952_ VPWR VGND sg13g2_a22oi_1
X_1631_ _1298_ _1314_ _1315_ VPWR VGND sg13g2_nor2_1
X_2957__165 VPWR VGND net165 sg13g2_tiehi
X_1562_ _1244_ _1245_ _1239_ _1247_ VPWR VGND sg13g2_nand3_1
XFILLER_4_692 VPWR VGND sg13g2_decap_8
XFILLER_39_324 VPWR VGND sg13g2_decap_8
X_2114_ _0586_ VPWR _0587_ VGND _0550_ _0585_ sg13g2_o21ai_1
XFILLER_39_357 VPWR VGND sg13g2_decap_8
X_2045_ _0518_ _0506_ _0520_ VPWR VGND sg13g2_xor2_1
XFILLER_10_408 VPWR VGND sg13g2_decap_8
X_2947_ net69 VGND VPWR _0104_ falutop.alu_data_in\[7\] clknet_4_15_0_clk sg13g2_dfrbpq_2
X_2878_ net52 VGND VPWR _0035_ falutop.data_in\[7\] net396 sg13g2_dfrbpq_2
X_1829_ VPWR VGND _0989_ _0308_ _1126_ _0985_ _0309_ _1119_ sg13g2_a221oi_1
XFILLER_38_35 VPWR VGND sg13g2_decap_8
XFILLER_46_806 VPWR VGND sg13g2_decap_8
XFILLER_45_305 VPWR VGND sg13g2_decap_8
XFILLER_26_574 VPWR VGND sg13g2_decap_8
XFILLER_41_533 VPWR VGND sg13g2_fill_1
XFILLER_13_224 VPWR VGND sg13g2_decap_8
XFILLER_9_206 VPWR VGND sg13g2_decap_4
XFILLER_13_268 VPWR VGND sg13g2_decap_4
XFILLER_6_902 VPWR VGND sg13g2_decap_8
XFILLER_10_953 VPWR VGND sg13g2_decap_8
XFILLER_21_290 VPWR VGND sg13g2_decap_8
XFILLER_6_979 VPWR VGND sg13g2_decap_8
XFILLER_5_478 VPWR VGND sg13g2_decap_8
XFILLER_1_651 VPWR VGND sg13g2_decap_8
XFILLER_49_611 VPWR VGND sg13g2_decap_8
XFILLER_0_161 VPWR VGND sg13g2_decap_8
XFILLER_49_699 VPWR VGND sg13g2_decap_8
XFILLER_36_327 VPWR VGND sg13g2_decap_4
XFILLER_36_349 VPWR VGND sg13g2_decap_8
XFILLER_44_393 VPWR VGND sg13g2_fill_1
XFILLER_32_533 VPWR VGND sg13g2_decap_8
XFILLER_20_728 VPWR VGND sg13g2_decap_8
X_2801_ _1037_ _1049_ _1139_ VPWR VGND sg13g2_nor2_1
XFILLER_12_290 VPWR VGND sg13g2_decap_8
X_2732_ _0756_ _1053_ _1072_ VPWR VGND sg13g2_nor2_2
XFILLER_9_784 VPWR VGND sg13g2_decap_8
XFILLER_8_283 VPWR VGND sg13g2_decap_8
X_2663_ _0989_ _0951_ _1003_ VPWR VGND sg13g2_xor2_1
X_2594_ VGND VPWR _0826_ net311 _0071_ _0941_ sg13g2_a21oi_1
X_1614_ VGND VPWR _1168_ _1212_ _1298_ _1211_ sg13g2_a21oi_1
XFILLER_5_72 VPWR VGND sg13g2_decap_8
X_1545_ VGND VPWR _1091_ _1096_ _1230_ _1032_ sg13g2_a21oi_1
XFILLER_39_187 VPWR VGND sg13g2_fill_1
X_2028_ _0464_ VPWR _0503_ VGND _0263_ _0463_ sg13g2_o21ai_1
XFILLER_39_1022 VPWR VGND sg13g2_decap_8
XFILLER_23_511 VPWR VGND sg13g2_decap_8
XFILLER_35_382 VPWR VGND sg13g2_decap_8
XFILLER_23_599 VPWR VGND sg13g2_decap_8
XFILLER_40_14 VPWR VGND sg13g2_decap_8
XFILLER_6_209 VPWR VGND sg13g2_decap_8
XFILLER_3_949 VPWR VGND sg13g2_decap_8
XFILLER_2_448 VPWR VGND sg13g2_decap_8
XFILLER_49_67 VPWR VGND sg13g2_fill_1
XFILLER_49_56 VPWR VGND sg13g2_decap_8
XFILLER_18_305 VPWR VGND sg13g2_decap_8
XFILLER_46_658 VPWR VGND sg13g2_decap_8
XFILLER_27_861 VPWR VGND sg13g2_decap_8
XFILLER_14_566 VPWR VGND sg13g2_decap_4
XFILLER_42_886 VPWR VGND sg13g2_decap_8
XFILLER_14_577 VPWR VGND sg13g2_decap_8
XFILLER_10_750 VPWR VGND sg13g2_decap_8
XFILLER_5_220 VPWR VGND sg13g2_decap_4
XFILLER_6_776 VPWR VGND sg13g2_decap_8
XFILLER_46_7 VPWR VGND sg13g2_decap_8
XFILLER_5_286 VPWR VGND sg13g2_decap_8
XFILLER_49_474 VPWR VGND sg13g2_decap_4
XFILLER_37_603 VPWR VGND sg13g2_decap_8
XFILLER_37_658 VPWR VGND sg13g2_decap_8
XFILLER_17_360 VPWR VGND sg13g2_fill_1
XFILLER_33_831 VPWR VGND sg13g2_decap_8
XFILLER_33_842 VPWR VGND sg13g2_fill_1
XFILLER_20_503 VPWR VGND sg13g2_decap_8
XFILLER_20_514 VPWR VGND sg13g2_decap_8
XFILLER_33_897 VPWR VGND sg13g2_decap_8
XFILLER_9_581 VPWR VGND sg13g2_decap_8
X_2715_ _1055_ net377 _1040_ VPWR VGND sg13g2_nand2_1
X_2646_ _0986_ _0755_ _0760_ VPWR VGND sg13g2_nand2_1
X_2577_ net405 VPWR _0933_ VGND net277 net313 sg13g2_o21ai_1
X_1528_ _1069_ VPWR _1213_ VGND _1168_ _1212_ sg13g2_o21ai_1
XFILLER_19_26 VPWR VGND sg13g2_decap_8
XFILLER_28_603 VPWR VGND sg13g2_decap_4
XFILLER_42_127 VPWR VGND sg13g2_decap_8
XFILLER_24_820 VPWR VGND sg13g2_decap_4
XFILLER_42_149 VPWR VGND sg13g2_decap_4
XFILLER_35_69 VPWR VGND sg13g2_decap_4
XFILLER_35_190 VPWR VGND sg13g2_fill_1
XFILLER_23_396 VPWR VGND sg13g2_decap_4
XFILLER_13_1003 VPWR VGND sg13g2_decap_8
XFILLER_3_746 VPWR VGND sg13g2_decap_8
XFILLER_2_256 VPWR VGND sg13g2_decap_8
XFILLER_47_945 VPWR VGND sg13g2_decap_8
XFILLER_18_124 VPWR VGND sg13g2_decap_8
XFILLER_46_444 VPWR VGND sg13g2_decap_4
XFILLER_33_116 VPWR VGND sg13g2_decap_8
XFILLER_15_842 VPWR VGND sg13g2_decap_8
XFILLER_42_650 VPWR VGND sg13g2_fill_2
XFILLER_30_867 VPWR VGND sg13g2_decap_8
X_2500_ net286 VPWR _0893_ VGND _0869_ _0888_ sg13g2_o21ai_1
XFILLER_6_573 VPWR VGND sg13g2_decap_8
X_2431_ _0835_ VPWR _0011_ VGND _0768_ _0838_ sg13g2_o21ai_1
XFILLER_29_1021 VPWR VGND sg13g2_decap_8
X_2362_ _0738_ net387 _0780_ VPWR VGND sg13g2_nor2_1
X_2293_ VGND VPWR net389 _0717_ _0140_ _0718_ sg13g2_a21oi_1
XFILLER_49_271 VPWR VGND sg13g2_decap_8
XFILLER_38_967 VPWR VGND sg13g2_decap_8
XFILLER_37_444 VPWR VGND sg13g2_decap_8
XFILLER_24_116 VPWR VGND sg13g2_decap_4
XFILLER_24_127 VPWR VGND sg13g2_decap_8
XFILLER_36_1014 VPWR VGND sg13g2_decap_8
XFILLER_21_834 VPWR VGND sg13g2_decap_8
XFILLER_20_388 VPWR VGND sg13g2_decap_4
X_2629_ _0969_ net346 net369 VPWR VGND sg13g2_nand2_2
XFILLER_43_1018 VPWR VGND sg13g2_decap_8
XFILLER_29_923 VPWR VGND sg13g2_decap_8
XFILLER_28_400 VPWR VGND sg13g2_decap_8
XFILLER_46_68 VPWR VGND sg13g2_decap_8
XFILLER_46_35 VPWR VGND sg13g2_decap_8
XFILLER_28_444 VPWR VGND sg13g2_decap_8
XFILLER_43_403 VPWR VGND sg13g2_decap_8
XFILLER_15_138 VPWR VGND sg13g2_decap_8
XFILLER_24_661 VPWR VGND sg13g2_decap_8
XFILLER_24_672 VPWR VGND sg13g2_fill_1
XFILLER_12_856 VPWR VGND sg13g2_decap_8
XFILLER_8_816 VPWR VGND sg13g2_decap_8
XFILLER_3_543 VPWR VGND sg13g2_decap_8
Xfanout390 net391 net390 VPWR VGND sg13g2_buf_1
XFILLER_16_8 VPWR VGND sg13g2_fill_1
XFILLER_19_422 VPWR VGND sg13g2_decap_8
XFILLER_47_742 VPWR VGND sg13g2_decap_8
XFILLER_19_455 VPWR VGND sg13g2_decap_8
XFILLER_46_274 VPWR VGND sg13g2_decap_8
XFILLER_35_948 VPWR VGND sg13g2_decap_8
XFILLER_15_661 VPWR VGND sg13g2_decap_8
X_2980_ net89 VGND VPWR _0137_ falutop.i2c_inst.data_in\[9\] net392 sg13g2_dfrbpq_1
XFILLER_14_171 VPWR VGND sg13g2_decap_8
XFILLER_15_683 VPWR VGND sg13g2_decap_8
X_1931_ falutop.div_inst.rem\[1\] falutop.div_inst.rem\[0\] net381 _0409_ VPWR VGND
+ sg13g2_nand3_1
XFILLER_14_193 VPWR VGND sg13g2_decap_4
XFILLER_30_664 VPWR VGND sg13g2_decap_4
X_1862_ net350 net357 _0341_ VPWR VGND sg13g2_nor2b_1
XFILLER_30_697 VPWR VGND sg13g2_decap_8
X_1793_ _0273_ _1328_ _0272_ VPWR VGND sg13g2_nand2_1
X_2414_ _0825_ net243 net282 VPWR VGND sg13g2_nand2_1
XFILLER_35_0 VPWR VGND sg13g2_decap_8
X_2345_ _0764_ net1 VPWR VGND sg13g2_inv_2
X_2276_ falutop.i2c_inst.counter\[4\] falutop.i2c_inst.counter\[3\] _0706_ VPWR VGND
+ sg13g2_nor2b_2
XFILLER_37_263 VPWR VGND sg13g2_decap_8
XFILLER_16_16 VPWR VGND sg13g2_decap_8
X_2967__145 VPWR VGND net145 sg13g2_tiehi
XFILLER_26_959 VPWR VGND sg13g2_decap_8
XFILLER_40_417 VPWR VGND sg13g2_decap_8
XFILLER_34_992 VPWR VGND sg13g2_decap_8
XFILLER_48_517 VPWR VGND sg13g2_fill_2
XFILLER_0_568 VPWR VGND sg13g2_decap_8
XFILLER_29_720 VPWR VGND sg13g2_fill_1
XFILLER_44_712 VPWR VGND sg13g2_decap_8
XFILLER_44_701 VPWR VGND sg13g2_fill_1
XFILLER_17_926 VPWR VGND sg13g2_decap_8
XFILLER_29_786 VPWR VGND sg13g2_decap_8
XFILLER_44_767 VPWR VGND sg13g2_decap_8
XFILLER_43_222 VPWR VGND sg13g2_decap_4
XFILLER_16_447 VPWR VGND sg13g2_decap_4
XFILLER_43_266 VPWR VGND sg13g2_decap_8
XFILLER_32_918 VPWR VGND sg13g2_decap_8
XFILLER_40_940 VPWR VGND sg13g2_decap_8
XFILLER_12_631 VPWR VGND sg13g2_decap_8
XFILLER_8_613 VPWR VGND sg13g2_decap_8
XFILLER_7_156 VPWR VGND sg13g2_decap_8
XFILLER_4_874 VPWR VGND sg13g2_decap_8
XFILLER_3_362 VPWR VGND sg13g2_decap_4
X_2130_ net292 _0601_ _0602_ _0603_ VPWR VGND sg13g2_nor3_1
X_2061_ falutop.div_inst.rem\[4\] _0494_ net381 _0536_ VPWR VGND sg13g2_nand3_1
XFILLER_47_583 VPWR VGND sg13g2_decap_8
XFILLER_19_252 VPWR VGND sg13g2_decap_4
XFILLER_35_723 VPWR VGND sg13g2_decap_8
XFILLER_35_756 VPWR VGND sg13g2_decap_8
XFILLER_22_406 VPWR VGND sg13g2_fill_1
XFILLER_23_918 VPWR VGND sg13g2_decap_8
XFILLER_16_981 VPWR VGND sg13g2_decap_8
X_2963_ net153 VGND VPWR _0120_ falutop.div_inst.a\[0\] clknet_4_6_0_clk sg13g2_dfrbpq_1
X_1914_ _0392_ _0368_ _0391_ VPWR VGND sg13g2_nand2b_1
XFILLER_31_962 VPWR VGND sg13g2_decap_8
X_2894_ net34 VGND VPWR net218 falutop.div_inst.i\[0\] clknet_4_11_0_clk sg13g2_dfrbpq_1
X_1845_ _0265_ VPWR _0324_ VGND _0196_ _0266_ sg13g2_o21ai_1
X_1776_ VPWR VGND net317 net307 _0256_ net290 _0257_ _0254_ sg13g2_a221oi_1
X_2328_ VPWR _0747_ net186 VGND sg13g2_inv_1
XFILLER_26_701 VPWR VGND sg13g2_fill_2
X_2259_ VGND VPWR net390 _0693_ _0130_ _0694_ sg13g2_a21oi_1
XFILLER_38_594 VPWR VGND sg13g2_decap_8
XFILLER_43_14 VPWR VGND sg13g2_decap_8
XFILLER_14_929 VPWR VGND sg13g2_decap_8
XFILLER_40_225 VPWR VGND sg13g2_decap_8
XFILLER_22_984 VPWR VGND sg13g2_decap_8
XFILLER_1_833 VPWR VGND sg13g2_decap_8
XFILLER_49_804 VPWR VGND sg13g2_decap_8
XFILLER_0_365 VPWR VGND sg13g2_decap_8
XFILLER_1_1015 VPWR VGND sg13g2_decap_8
XFILLER_16_211 VPWR VGND sg13g2_fill_2
XFILLER_16_222 VPWR VGND sg13g2_decap_8
XFILLER_44_597 VPWR VGND sg13g2_decap_8
XFILLER_44_586 VPWR VGND sg13g2_fill_2
XFILLER_31_203 VPWR VGND sg13g2_decap_8
XFILLER_13_940 VPWR VGND sg13g2_decap_8
XFILLER_40_781 VPWR VGND sg13g2_decap_8
XFILLER_9_966 VPWR VGND sg13g2_decap_8
XFILLER_8_487 VPWR VGND sg13g2_decap_8
X_1630_ _1314_ _1204_ _1313_ VPWR VGND sg13g2_xnor2_1
XFILLER_4_671 VPWR VGND sg13g2_decap_8
X_1561_ _1246_ _1239_ _1244_ _1245_ VPWR VGND sg13g2_and3_1
XFILLER_39_303 VPWR VGND sg13g2_fill_2
X_2113_ _0586_ _0425_ _0551_ net356 net323 VPWR VGND sg13g2_a22oi_1
XFILLER_48_892 VPWR VGND sg13g2_decap_8
X_2044_ _0518_ _0506_ _0519_ VPWR VGND sg13g2_nor2b_1
XFILLER_35_575 VPWR VGND sg13g2_fill_2
XFILLER_22_214 VPWR VGND sg13g2_decap_4
XFILLER_23_748 VPWR VGND sg13g2_decap_8
X_2946_ net71 VGND VPWR _0103_ falutop.alu_data_in\[6\] clknet_4_15_0_clk sg13g2_dfrbpq_1
X_2877_ net53 VGND VPWR _0034_ falutop.data_in\[6\] net397 sg13g2_dfrbpq_2
X_1828_ _0308_ _0306_ _0307_ VPWR VGND sg13g2_nand2_1
X_1759_ _0239_ VPWR _0240_ VGND net334 net280 sg13g2_o21ai_1
XFILLER_38_14 VPWR VGND sg13g2_decap_8
XFILLER_18_509 VPWR VGND sg13g2_decap_8
XFILLER_26_531 VPWR VGND sg13g2_decap_8
XFILLER_41_501 VPWR VGND sg13g2_fill_1
XFILLER_13_203 VPWR VGND sg13g2_decap_8
XFILLER_41_589 VPWR VGND sg13g2_decap_8
XFILLER_16_1023 VPWR VGND sg13g2_decap_4
XFILLER_10_932 VPWR VGND sg13g2_decap_8
XFILLER_22_792 VPWR VGND sg13g2_decap_4
XFILLER_5_413 VPWR VGND sg13g2_decap_8
XFILLER_6_958 VPWR VGND sg13g2_decap_8
XFILLER_5_457 VPWR VGND sg13g2_decap_8
XFILLER_1_630 VPWR VGND sg13g2_decap_8
XFILLER_0_140 VPWR VGND sg13g2_decap_8
XFILLER_23_1016 VPWR VGND sg13g2_decap_8
XFILLER_23_1027 VPWR VGND sg13g2_fill_2
XFILLER_49_678 VPWR VGND sg13g2_decap_8
XFILLER_37_818 VPWR VGND sg13g2_decap_8
XFILLER_17_520 VPWR VGND sg13g2_fill_2
XFILLER_28_91 VPWR VGND sg13g2_decap_8
XFILLER_44_350 VPWR VGND sg13g2_fill_2
XFILLER_45_884 VPWR VGND sg13g2_decap_8
XFILLER_32_567 VPWR VGND sg13g2_decap_4
XFILLER_44_90 VPWR VGND sg13g2_decap_8
X_2800_ net178 VPWR _0080_ VGND _1133_ _1138_ sg13g2_o21ai_1
XFILLER_9_763 VPWR VGND sg13g2_decap_8
X_2731_ net378 net377 _0992_ _1071_ VPWR VGND sg13g2_nor3_2
XFILLER_8_240 VPWR VGND sg13g2_decap_4
X_2662_ _0951_ _0989_ _1002_ VPWR VGND sg13g2_and2_1
X_2593_ net400 VPWR _0941_ VGND net420 net311 sg13g2_o21ai_1
X_1613_ _1296_ VPWR _1297_ VGND _1116_ _1290_ sg13g2_o21ai_1
XFILLER_5_51 VPWR VGND sg13g2_decap_8
X_1544_ _1022_ _1228_ net352 _1229_ VPWR VGND sg13g2_nand3_1
Xclkbuf_4_7_0_clk clknet_0_clk clknet_4_7_0_clk VPWR VGND sg13g2_buf_8
XFILLER_39_111 VPWR VGND sg13g2_decap_8
XFILLER_28_818 VPWR VGND sg13g2_decap_8
X_2027_ VGND VPWR _0461_ _0478_ _0502_ _0477_ sg13g2_a21oi_1
XFILLER_39_1001 VPWR VGND sg13g2_decap_8
XFILLER_36_895 VPWR VGND sg13g2_decap_8
XFILLER_35_372 VPWR VGND sg13g2_fill_1
XFILLER_23_534 VPWR VGND sg13g2_decap_8
XFILLER_11_729 VPWR VGND sg13g2_decap_8
XFILLER_10_239 VPWR VGND sg13g2_decap_8
X_2929_ net120 VGND VPWR _0086_ falutop.i2c_inst.result\[7\] clknet_4_13_0_clk sg13g2_dfrbpq_1
XFILLER_3_928 VPWR VGND sg13g2_decap_8
XFILLER_2_427 VPWR VGND sg13g2_decap_8
XFILLER_49_35 VPWR VGND sg13g2_decap_8
XFILLER_46_1027 VPWR VGND sg13g2_fill_2
XFILLER_46_1016 VPWR VGND sg13g2_decap_8
XFILLER_49_79 VPWR VGND sg13g2_decap_8
XFILLER_19_818 VPWR VGND sg13g2_decap_8
XFILLER_46_637 VPWR VGND sg13g2_decap_8
XFILLER_14_512 VPWR VGND sg13g2_fill_1
XFILLER_42_865 VPWR VGND sg13g2_decap_8
XFILLER_14_534 VPWR VGND sg13g2_decap_8
XFILLER_41_397 VPWR VGND sg13g2_decap_8
XFILLER_14_60 VPWR VGND sg13g2_decap_8
XFILLER_6_755 VPWR VGND sg13g2_decap_8
XFILLER_5_265 VPWR VGND sg13g2_fill_2
XFILLER_7_1010 VPWR VGND sg13g2_decap_8
XFILLER_2_994 VPWR VGND sg13g2_decap_8
XFILLER_49_453 VPWR VGND sg13g2_decap_8
XFILLER_39_90 VPWR VGND sg13g2_decap_4
XFILLER_18_884 VPWR VGND sg13g2_decap_8
XFILLER_33_876 VPWR VGND sg13g2_decap_8
XFILLER_20_537 VPWR VGND sg13g2_decap_8
XFILLER_9_560 VPWR VGND sg13g2_decap_8
XFILLER_20_559 VPWR VGND sg13g2_decap_8
X_2714_ _1054_ _1052_ _0998_ _1051_ _1000_ VPWR VGND sg13g2_a22oi_1
X_2645_ net331 net356 _0985_ VPWR VGND sg13g2_nor2_2
X_2576_ net283 net312 _0932_ VPWR VGND sg13g2_nor2b_1
X_1527_ _1210_ _1166_ _1212_ VPWR VGND sg13g2_xor2_1
XFILLER_19_49 VPWR VGND sg13g2_fill_1
XFILLER_28_626 VPWR VGND sg13g2_decap_8
XFILLER_43_618 VPWR VGND sg13g2_decap_8
XFILLER_35_26 VPWR VGND sg13g2_decap_8
XFILLER_36_692 VPWR VGND sg13g2_decap_8
XFILLER_23_353 VPWR VGND sg13g2_decap_8
XFILLER_23_375 VPWR VGND sg13g2_decap_8
XFILLER_24_898 VPWR VGND sg13g2_decap_8
XFILLER_3_725 VPWR VGND sg13g2_decap_8
XFILLER_2_202 VPWR VGND sg13g2_decap_8
XFILLER_4_4 VPWR VGND sg13g2_decap_8
XFILLER_47_924 VPWR VGND sg13g2_decap_8
XFILLER_46_423 VPWR VGND sg13g2_decap_8
XFILLER_19_659 VPWR VGND sg13g2_fill_2
XFILLER_15_821 VPWR VGND sg13g2_decap_8
XFILLER_27_681 VPWR VGND sg13g2_decap_8
XFILLER_33_106 VPWR VGND sg13g2_decap_4
XFILLER_41_150 VPWR VGND sg13g2_decap_8
XFILLER_15_898 VPWR VGND sg13g2_decap_8
XFILLER_30_824 VPWR VGND sg13g2_decap_8
XFILLER_30_835 VPWR VGND sg13g2_fill_1
XFILLER_6_552 VPWR VGND sg13g2_decap_8
X_2430_ _0837_ VPWR _0838_ VGND net211 net282 sg13g2_o21ai_1
XFILLER_29_1000 VPWR VGND sg13g2_decap_8
X_2361_ VGND VPWR net288 _0778_ _0000_ _0779_ sg13g2_a21oi_1
X_2292_ net401 VPWR _0718_ VGND falutop.i2c_inst.data_in\[12\] _0717_ sg13g2_o21ai_1
XFILLER_2_791 VPWR VGND sg13g2_decap_8
XFILLER_38_946 VPWR VGND sg13g2_decap_8
XFILLER_37_423 VPWR VGND sg13g2_decap_8
XFILLER_2_85 VPWR VGND sg13g2_decap_8
XFILLER_37_478 VPWR VGND sg13g2_decap_4
XFILLER_37_489 VPWR VGND sg13g2_decap_4
XFILLER_18_670 VPWR VGND sg13g2_decap_8
XFILLER_21_813 VPWR VGND sg13g2_decap_8
XFILLER_20_301 VPWR VGND sg13g2_fill_2
XFILLER_20_367 VPWR VGND sg13g2_decap_8
X_2628_ net347 net369 _0968_ VPWR VGND sg13g2_and2_1
X_2559_ _0051_ net217 _0766_ _0925_ _0765_ VPWR VGND sg13g2_a22oi_1
XFILLER_29_902 VPWR VGND sg13g2_decap_8
XFILLER_46_14 VPWR VGND sg13g2_decap_8
XFILLER_28_423 VPWR VGND sg13g2_fill_1
XFILLER_29_979 VPWR VGND sg13g2_decap_8
XFILLER_44_949 VPWR VGND sg13g2_decap_8
XFILLER_15_106 VPWR VGND sg13g2_decap_8
XFILLER_15_117 VPWR VGND sg13g2_fill_2
XFILLER_43_459 VPWR VGND sg13g2_decap_8
XFILLER_12_835 VPWR VGND sg13g2_decap_8
XFILLER_11_356 VPWR VGND sg13g2_decap_8
XFILLER_7_338 VPWR VGND sg13g2_decap_8
XFILLER_3_522 VPWR VGND sg13g2_decap_8
XFILLER_11_61 VPWR VGND sg13g2_fill_1
XFILLER_3_599 VPWR VGND sg13g2_decap_8
XFILLER_47_721 VPWR VGND sg13g2_decap_8
Xfanout391 _0731_ net391 VPWR VGND sg13g2_buf_8
Xfanout380 falutop.alu_inst.op\[1\] net380 VPWR VGND sg13g2_buf_8
XFILLER_47_798 VPWR VGND sg13g2_decap_8
XFILLER_35_927 VPWR VGND sg13g2_decap_8
XFILLER_42_470 VPWR VGND sg13g2_decap_8
X_1930_ VGND VPWR net381 falutop.div_inst.rem\[0\] _0408_ falutop.div_inst.rem\[1\]
+ sg13g2_a21oi_1
XFILLER_30_632 VPWR VGND sg13g2_decap_8
X_1861_ _0340_ net337 net367 VPWR VGND sg13g2_nand2_1
XFILLER_11_890 VPWR VGND sg13g2_decap_8
X_1792_ net346 net359 _0272_ VPWR VGND sg13g2_and2_1
X_2413_ _0823_ VPWR _0824_ VGND falutop.div_inst.b1\[7\] _0747_ sg13g2_o21ai_1
X_2344_ _0763_ net368 VPWR VGND sg13g2_inv_2
X_2275_ VGND VPWR _0731_ _0704_ _0135_ _0705_ sg13g2_a21oi_1
XFILLER_26_938 VPWR VGND sg13g2_decap_8
XFILLER_37_297 VPWR VGND sg13g2_fill_2
XFILLER_41_919 VPWR VGND sg13g2_decap_8
XFILLER_25_459 VPWR VGND sg13g2_decap_4
XFILLER_34_971 VPWR VGND sg13g2_decap_8
XFILLER_32_49 VPWR VGND sg13g2_fill_2
XFILLER_0_547 VPWR VGND sg13g2_decap_8
XFILLER_17_905 VPWR VGND sg13g2_decap_8
XFILLER_43_201 VPWR VGND sg13g2_decap_8
X_2911__156 VPWR VGND net156 sg13g2_tiehi
XFILLER_28_253 VPWR VGND sg13g2_fill_1
XFILLER_44_746 VPWR VGND sg13g2_decap_8
XFILLER_43_245 VPWR VGND sg13g2_decap_8
XFILLER_19_1010 VPWR VGND sg13g2_decap_8
XFILLER_24_481 VPWR VGND sg13g2_decap_8
XFILLER_11_131 VPWR VGND sg13g2_fill_2
XFILLER_40_996 VPWR VGND sg13g2_decap_8
XFILLER_11_153 VPWR VGND sg13g2_decap_8
XFILLER_12_687 VPWR VGND sg13g2_decap_8
XFILLER_8_669 VPWR VGND sg13g2_decap_8
XFILLER_11_186 VPWR VGND sg13g2_fill_1
XFILLER_4_853 VPWR VGND sg13g2_decap_8
XFILLER_3_341 VPWR VGND sg13g2_decap_8
XFILLER_39_518 VPWR VGND sg13g2_fill_1
X_2060_ _0494_ net381 falutop.div_inst.rem\[4\] _0535_ VPWR VGND sg13g2_a21o_1
XFILLER_19_275 VPWR VGND sg13g2_fill_2
XFILLER_16_960 VPWR VGND sg13g2_decap_8
X_2962_ net155 VGND VPWR _0119_ falutop.div_inst.b\[6\] clknet_4_3_0_clk sg13g2_dfrbpq_1
XFILLER_15_481 VPWR VGND sg13g2_decap_8
XFILLER_22_429 VPWR VGND sg13g2_decap_4
X_1913_ _0391_ _0375_ _0390_ VPWR VGND sg13g2_xnor2_1
XFILLER_31_941 VPWR VGND sg13g2_decap_8
X_2893_ net35 VGND VPWR _0050_ falutop.alu_inst.op\[3\] clknet_4_15_0_clk sg13g2_dfrbpq_2
X_1844_ VGND VPWR _0270_ _0284_ _0323_ _0283_ sg13g2_a21oi_1
X_1775_ _0256_ net226 _0255_ VPWR VGND sg13g2_xnor2_1
X_2327_ _0746_ falutop.i2c_inst.op\[2\] VPWR VGND sg13g2_inv_2
X_2258_ net402 VPWR _0694_ VGND falutop.i2c_inst.data_in\[2\] _0693_ sg13g2_o21ai_1
XFILLER_38_562 VPWR VGND sg13g2_fill_1
XFILLER_38_551 VPWR VGND sg13g2_decap_8
X_2849__96 VPWR VGND net96 sg13g2_tiehi
X_2189_ falutop.data_in\[13\] net297 _0645_ VPWR VGND sg13g2_nor2_1
XFILLER_26_746 VPWR VGND sg13g2_decap_8
XFILLER_14_908 VPWR VGND sg13g2_decap_8
XFILLER_25_234 VPWR VGND sg13g2_decap_8
XFILLER_41_738 VPWR VGND sg13g2_decap_8
XFILLER_40_215 VPWR VGND sg13g2_fill_1
XFILLER_13_418 VPWR VGND sg13g2_decap_4
XFILLER_22_963 VPWR VGND sg13g2_decap_8
XFILLER_21_484 VPWR VGND sg13g2_decap_8
XFILLER_5_639 VPWR VGND sg13g2_decap_8
XFILLER_49_1014 VPWR VGND sg13g2_decap_8
XFILLER_4_149 VPWR VGND sg13g2_decap_4
XFILLER_1_812 VPWR VGND sg13g2_decap_8
XFILLER_1_889 VPWR VGND sg13g2_decap_8
XFILLER_48_337 VPWR VGND sg13g2_decap_8
XFILLER_29_551 VPWR VGND sg13g2_fill_1
XFILLER_31_226 VPWR VGND sg13g2_fill_1
XFILLER_40_760 VPWR VGND sg13g2_decap_8
XFILLER_9_945 VPWR VGND sg13g2_decap_8
XFILLER_13_996 VPWR VGND sg13g2_decap_8
XFILLER_33_92 VPWR VGND sg13g2_decap_8
XFILLER_8_466 VPWR VGND sg13g2_decap_8
X_1560_ _1240_ VPWR _1245_ VGND _1241_ _1243_ sg13g2_o21ai_1
XFILLER_4_650 VPWR VGND sg13g2_decap_8
X_2112_ net368 _0551_ _0585_ VPWR VGND sg13g2_nor2_1
XFILLER_48_871 VPWR VGND sg13g2_decap_8
XFILLER_47_392 VPWR VGND sg13g2_decap_8
X_2043_ _0518_ _0510_ _0517_ VPWR VGND sg13g2_xnor2_1
XFILLER_35_532 VPWR VGND sg13g2_fill_2
X_2846__99 VPWR VGND net99 sg13g2_tiehi
XFILLER_35_565 VPWR VGND sg13g2_decap_4
XFILLER_35_587 VPWR VGND sg13g2_decap_8
X_2945_ net73 VGND VPWR _0102_ falutop.alu_data_in\[5\] clknet_4_15_0_clk sg13g2_dfrbpq_1
X_2876_ net54 VGND VPWR _0033_ falutop.data_in\[5\] net397 sg13g2_dfrbpq_2
XFILLER_30_292 VPWR VGND sg13g2_decap_8
X_1827_ _0307_ _1045_ _0986_ _0993_ _0987_ VPWR VGND sg13g2_a22oi_1
XFILLER_2_609 VPWR VGND sg13g2_decap_8
X_1758_ VGND VPWR _0761_ net280 _0239_ _0995_ sg13g2_a21oi_1
X_1689_ _0171_ _0170_ VPWR VGND _0169_ sg13g2_nand2b_2
XFILLER_39_860 VPWR VGND sg13g2_decap_8
XFILLER_39_882 VPWR VGND sg13g2_decap_8
XFILLER_26_598 VPWR VGND sg13g2_decap_8
XFILLER_16_1002 VPWR VGND sg13g2_decap_8
XFILLER_10_911 VPWR VGND sg13g2_decap_8
XFILLER_22_771 VPWR VGND sg13g2_fill_1
XFILLER_6_937 VPWR VGND sg13g2_decap_8
XFILLER_10_988 VPWR VGND sg13g2_decap_8
XFILLER_5_436 VPWR VGND sg13g2_decap_8
XFILLER_1_686 VPWR VGND sg13g2_decap_8
XFILLER_49_657 VPWR VGND sg13g2_decap_8
XFILLER_28_70 VPWR VGND sg13g2_decap_8
XFILLER_45_863 VPWR VGND sg13g2_decap_8
XFILLER_17_554 VPWR VGND sg13g2_fill_2
XFILLER_17_576 VPWR VGND sg13g2_fill_2
XFILLER_32_513 VPWR VGND sg13g2_decap_4
XFILLER_32_524 VPWR VGND sg13g2_fill_2
XFILLER_32_546 VPWR VGND sg13g2_decap_8
XFILLER_40_590 VPWR VGND sg13g2_decap_8
XFILLER_9_742 VPWR VGND sg13g2_decap_8
XFILLER_13_793 VPWR VGND sg13g2_decap_8
X_2730_ VGND VPWR _1070_ _1012_ _0992_ sg13g2_or2_1
X_2661_ _0998_ _0999_ _1001_ VPWR VGND sg13g2_nor2_1
X_1612_ _1228_ _1293_ _1294_ _1295_ _1296_ VPWR VGND sg13g2_nor4_1
X_2592_ VGND VPWR _0733_ net309 _0070_ _0940_ sg13g2_a21oi_1
X_1543_ net284 _1031_ _1228_ VPWR VGND sg13g2_nor2_1
XFILLER_39_178 VPWR VGND sg13g2_decap_8
XFILLER_27_329 VPWR VGND sg13g2_decap_8
X_2026_ _0481_ VPWR _0501_ VGND _0458_ _0479_ sg13g2_o21ai_1
XFILLER_36_852 VPWR VGND sg13g2_fill_2
XFILLER_11_708 VPWR VGND sg13g2_decap_8
XFILLER_23_568 VPWR VGND sg13g2_decap_8
X_2928_ net122 VGND VPWR _0085_ falutop.i2c_inst.result\[6\] clknet_4_12_0_clk sg13g2_dfrbpq_1
XFILLER_31_590 VPWR VGND sg13g2_decap_8
X_2859_ net78 VGND VPWR _0016_ falutop.i2c_inst.op\[0\] net398 sg13g2_dfrbpq_1
XFILLER_40_49 VPWR VGND sg13g2_decap_8
XFILLER_3_907 VPWR VGND sg13g2_decap_8
XFILLER_2_406 VPWR VGND sg13g2_decap_8
XFILLER_49_14 VPWR VGND sg13g2_decap_8
XFILLER_46_616 VPWR VGND sg13g2_decap_8
XFILLER_45_159 VPWR VGND sg13g2_decap_4
XFILLER_26_362 VPWR VGND sg13g2_fill_1
XFILLER_27_896 VPWR VGND sg13g2_decap_8
XFILLER_42_844 VPWR VGND sg13g2_decap_8
XFILLER_26_395 VPWR VGND sg13g2_decap_4
XFILLER_6_734 VPWR VGND sg13g2_decap_8
XFILLER_10_785 VPWR VGND sg13g2_decap_8
XFILLER_30_82 VPWR VGND sg13g2_decap_8
XFILLER_30_93 VPWR VGND sg13g2_fill_1
XFILLER_2_973 VPWR VGND sg13g2_decap_8
XFILLER_49_432 VPWR VGND sg13g2_decap_8
XFILLER_49_421 VPWR VGND sg13g2_decap_8
XFILLER_1_483 VPWR VGND sg13g2_decap_8
XFILLER_49_498 VPWR VGND sg13g2_decap_8
XFILLER_37_638 VPWR VGND sg13g2_fill_2
XFILLER_37_627 VPWR VGND sg13g2_decap_8
XFILLER_18_863 VPWR VGND sg13g2_decap_8
XFILLER_36_148 VPWR VGND sg13g2_decap_4
XFILLER_17_373 VPWR VGND sg13g2_fill_1
X_2713_ _1053_ net380 _1050_ VPWR VGND sg13g2_nand2_2
X_2644_ _0950_ VPWR _0984_ VGND net328 _0760_ sg13g2_o21ai_1
X_2575_ net400 net288 _0062_ VPWR VGND sg13g2_and2_1
X_1526_ _1166_ _1210_ _1211_ VPWR VGND sg13g2_and2_1
XFILLER_27_126 VPWR VGND sg13g2_decap_4
XFILLER_28_649 VPWR VGND sg13g2_decap_8
XFILLER_27_148 VPWR VGND sg13g2_decap_8
XFILLER_36_660 VPWR VGND sg13g2_decap_8
X_2009_ _0440_ _0482_ _0438_ _0485_ VPWR VGND sg13g2_nand3_1
XFILLER_23_343 VPWR VGND sg13g2_fill_2
XFILLER_24_877 VPWR VGND sg13g2_decap_8
XFILLER_3_704 VPWR VGND sg13g2_decap_8
X_2889__39 VPWR VGND net39 sg13g2_tiehi
XFILLER_47_903 VPWR VGND sg13g2_decap_8
XFILLER_46_402 VPWR VGND sg13g2_decap_8
XFILLER_46_468 VPWR VGND sg13g2_decap_8
XFILLER_18_159 VPWR VGND sg13g2_decap_8
XFILLER_34_608 VPWR VGND sg13g2_decap_8
XFILLER_15_800 VPWR VGND sg13g2_decap_8
XFILLER_26_181 VPWR VGND sg13g2_decap_8
XFILLER_42_652 VPWR VGND sg13g2_fill_1
XFILLER_14_343 VPWR VGND sg13g2_decap_8
XFILLER_15_877 VPWR VGND sg13g2_decap_8
XFILLER_25_71 VPWR VGND sg13g2_decap_8
XFILLER_30_803 VPWR VGND sg13g2_decap_8
XFILLER_30_814 VPWR VGND sg13g2_fill_2
Xclkbuf_4_6_0_clk clknet_0_clk clknet_4_6_0_clk VPWR VGND sg13g2_buf_8
X_2921__136 VPWR VGND net136 sg13g2_tiehi
XFILLER_41_81 VPWR VGND sg13g2_decap_8
XFILLER_6_531 VPWR VGND sg13g2_decap_8
XFILLER_10_582 VPWR VGND sg13g2_decap_8
X_2360_ net188 net288 _0779_ VPWR VGND sg13g2_nor2_1
X_2291_ _0877_ _0716_ _0717_ VPWR VGND sg13g2_nor2_1
XFILLER_2_770 VPWR VGND sg13g2_decap_8
XFILLER_49_251 VPWR VGND sg13g2_decap_8
XFILLER_2_53 VPWR VGND sg13g2_decap_8
XFILLER_38_925 VPWR VGND sg13g2_decap_8
XFILLER_37_402 VPWR VGND sg13g2_decap_8
XFILLER_33_696 VPWR VGND sg13g2_decap_4
XFILLER_32_184 VPWR VGND sg13g2_decap_8
XFILLER_9_380 VPWR VGND sg13g2_decap_8
X_2627_ _0967_ _0751_ net371 VPWR VGND sg13g2_nand2_1
X_2558_ _0926_ net216 net388 VPWR VGND sg13g2_nand2b_1
XFILLER_0_729 VPWR VGND sg13g2_decap_8
X_2489_ _0871_ _0884_ _0885_ VPWR VGND sg13g2_nor2_1
X_1509_ VGND VPWR net224 _1193_ _1195_ net315 sg13g2_a21oi_1
XFILLER_29_958 VPWR VGND sg13g2_decap_8
XFILLER_44_928 VPWR VGND sg13g2_decap_8
XFILLER_16_619 VPWR VGND sg13g2_decap_8
XFILLER_11_313 VPWR VGND sg13g2_decap_8
XFILLER_12_814 VPWR VGND sg13g2_decap_8
XFILLER_23_173 VPWR VGND sg13g2_decap_8
XFILLER_24_696 VPWR VGND sg13g2_decap_8
X_2949__65 VPWR VGND net65 sg13g2_tiehi
XFILLER_20_880 VPWR VGND sg13g2_decap_8
XFILLER_3_501 VPWR VGND sg13g2_decap_8
XFILLER_3_578 VPWR VGND sg13g2_decap_8
XFILLER_11_95 VPWR VGND sg13g2_decap_8
XFILLER_47_700 VPWR VGND sg13g2_decap_8
Xfanout392 net394 net392 VPWR VGND sg13g2_buf_8
XFILLER_4_1014 VPWR VGND sg13g2_decap_8
Xfanout381 net382 net381 VPWR VGND sg13g2_buf_8
Xfanout370 net371 net370 VPWR VGND sg13g2_buf_8
XFILLER_19_435 VPWR VGND sg13g2_decap_8
XFILLER_35_906 VPWR VGND sg13g2_decap_8
XFILLER_47_777 VPWR VGND sg13g2_decap_8
XFILLER_46_287 VPWR VGND sg13g2_decap_8
XFILLER_34_427 VPWR VGND sg13g2_decap_8
XFILLER_43_983 VPWR VGND sg13g2_decap_8
XFILLER_42_482 VPWR VGND sg13g2_decap_8
XFILLER_14_184 VPWR VGND sg13g2_decap_4
X_1860_ VGND VPWR net353 _0277_ _0339_ _0760_ sg13g2_a21oi_1
X_1791_ _0271_ net344 net363 VPWR VGND sg13g2_nand2_1
XFILLER_7_884 VPWR VGND sg13g2_decap_8
X_2412_ net220 _0822_ _0823_ VPWR VGND sg13g2_nor2_1
X_2343_ VPWR _0762_ net365 VGND sg13g2_inv_1
X_2274_ net403 VPWR _0705_ VGND falutop.i2c_inst.data_in\[7\] _0704_ sg13g2_o21ai_1
XFILLER_38_722 VPWR VGND sg13g2_decap_4
XFILLER_38_755 VPWR VGND sg13g2_decap_8
XFILLER_37_210 VPWR VGND sg13g2_decap_4
XFILLER_38_788 VPWR VGND sg13g2_fill_1
XFILLER_26_917 VPWR VGND sg13g2_decap_8
XFILLER_25_438 VPWR VGND sg13g2_decap_8
XFILLER_34_950 VPWR VGND sg13g2_decap_8
XFILLER_33_482 VPWR VGND sg13g2_decap_8
XFILLER_21_633 VPWR VGND sg13g2_decap_8
XFILLER_32_28 VPWR VGND sg13g2_decap_8
XFILLER_21_688 VPWR VGND sg13g2_decap_8
X_1989_ VGND VPWR net332 _1329_ _0465_ _0463_ sg13g2_a21oi_1
XFILLER_0_526 VPWR VGND sg13g2_decap_8
XFILLER_48_519 VPWR VGND sg13g2_fill_1
XFILLER_29_755 VPWR VGND sg13g2_decap_8
XFILLER_31_408 VPWR VGND sg13g2_decap_8
XFILLER_25_994 VPWR VGND sg13g2_decap_8
XFILLER_40_975 VPWR VGND sg13g2_decap_8
XFILLER_11_165 VPWR VGND sg13g2_decap_8
XFILLER_12_666 VPWR VGND sg13g2_decap_8
XFILLER_8_648 VPWR VGND sg13g2_decap_8
XFILLER_4_832 VPWR VGND sg13g2_decap_8
XFILLER_3_320 VPWR VGND sg13g2_decap_8
XFILLER_26_1015 VPWR VGND sg13g2_decap_8
XFILLER_34_202 VPWR VGND sg13g2_decap_8
XFILLER_34_235 VPWR VGND sg13g2_decap_8
XFILLER_43_780 VPWR VGND sg13g2_decap_8
X_2961_ net157 VGND VPWR _0118_ falutop.div_inst.b\[5\] clknet_4_3_0_clk sg13g2_dfrbpq_1
XFILLER_15_460 VPWR VGND sg13g2_decap_8
XFILLER_31_920 VPWR VGND sg13g2_decap_8
XFILLER_34_268 VPWR VGND sg13g2_decap_4
X_1912_ _0390_ _0376_ _0388_ VPWR VGND sg13g2_xnor2_1
X_2892_ net36 VGND VPWR _0049_ falutop.alu_inst.op\[2\] clknet_4_14_0_clk sg13g2_dfrbpq_1
XFILLER_30_441 VPWR VGND sg13g2_fill_2
XFILLER_31_997 VPWR VGND sg13g2_decap_8
X_1843_ _0268_ VPWR _0322_ VGND _0197_ _0269_ sg13g2_o21ai_1
XFILLER_30_496 VPWR VGND sg13g2_decap_8
XFILLER_8_96 VPWR VGND sg13g2_fill_2
X_1774_ _0255_ net318 _0186_ VPWR VGND sg13g2_nand2_1
XFILLER_7_681 VPWR VGND sg13g2_decap_8
XFILLER_40_0 VPWR VGND sg13g2_decap_8
X_2326_ _0745_ falutop.i2c_inst.op\[3\] VPWR VGND sg13g2_inv_2
X_2257_ _0863_ _0692_ _0693_ VPWR VGND sg13g2_nor2_1
X_2188_ VGND VPWR _0753_ net295 _0109_ _0644_ sg13g2_a21oi_1
XFILLER_26_725 VPWR VGND sg13g2_decap_8
XFILLER_26_769 VPWR VGND sg13g2_decap_8
XFILLER_41_728 VPWR VGND sg13g2_fill_2
XFILLER_41_717 VPWR VGND sg13g2_decap_8
XFILLER_43_49 VPWR VGND sg13g2_decap_8
XFILLER_22_942 VPWR VGND sg13g2_decap_8
XFILLER_5_618 VPWR VGND sg13g2_decap_8
XFILLER_0_323 VPWR VGND sg13g2_decap_8
XFILLER_1_868 VPWR VGND sg13g2_decap_8
XFILLER_49_839 VPWR VGND sg13g2_decap_8
XFILLER_17_703 VPWR VGND sg13g2_decap_4
XFILLER_17_725 VPWR VGND sg13g2_decap_8
XFILLER_17_61 VPWR VGND sg13g2_decap_8
XFILLER_17_758 VPWR VGND sg13g2_decap_8
XFILLER_44_588 VPWR VGND sg13g2_fill_1
XFILLER_32_717 VPWR VGND sg13g2_decap_8
XFILLER_32_728 VPWR VGND sg13g2_fill_2
XFILLER_25_791 VPWR VGND sg13g2_decap_4
XFILLER_9_924 VPWR VGND sg13g2_decap_8
XFILLER_12_463 VPWR VGND sg13g2_fill_2
XFILLER_13_975 VPWR VGND sg13g2_decap_8
XFILLER_12_485 VPWR VGND sg13g2_fill_1
XFILLER_33_71 VPWR VGND sg13g2_decap_8
XFILLER_39_305 VPWR VGND sg13g2_fill_1
X_3160_ falutop.i2c_inst.sda_o net4 VPWR VGND sg13g2_buf_2
X_2111_ _0555_ VPWR _0584_ VGND _0549_ _0553_ sg13g2_o21ai_1
XFILLER_39_338 VPWR VGND sg13g2_decap_8
XFILLER_0_890 VPWR VGND sg13g2_decap_8
XFILLER_12_4 VPWR VGND sg13g2_decap_4
Xhold1 falutop.div_inst.a\[3\] VPWR VGND net175 sg13g2_dlygate4sd3_1
XFILLER_48_850 VPWR VGND sg13g2_decap_8
X_2042_ _0517_ _0511_ _0515_ VPWR VGND sg13g2_xnor2_1
XFILLER_47_371 VPWR VGND sg13g2_fill_2
XFILLER_35_511 VPWR VGND sg13g2_decap_8
XFILLER_35_577 VPWR VGND sg13g2_fill_1
XFILLER_22_238 VPWR VGND sg13g2_decap_8
X_2944_ net79 VGND VPWR _0101_ falutop.alu_data_in\[4\] clknet_4_14_0_clk sg13g2_dfrbpq_1
X_2875_ net55 VGND VPWR _0032_ falutop.data_in\[4\] net397 sg13g2_dfrbpq_2
X_1826_ _0306_ _1072_ _0990_ _1051_ _0988_ VPWR VGND sg13g2_a22oi_1
X_1757_ _0236_ _0237_ net308 _0238_ VPWR VGND sg13g2_nand3_1
X_1688_ _0168_ VPWR _0170_ VGND _0166_ _0167_ sg13g2_o21ai_1
X_2309_ _0684_ _0692_ _0729_ VPWR VGND sg13g2_nor2_1
XFILLER_38_49 VPWR VGND sg13g2_decap_8
XFILLER_45_319 VPWR VGND sg13g2_decap_8
XFILLER_26_500 VPWR VGND sg13g2_decap_8
XFILLER_13_238 VPWR VGND sg13g2_decap_8
XFILLER_22_750 VPWR VGND sg13g2_decap_8
XFILLER_6_916 VPWR VGND sg13g2_decap_8
XFILLER_10_967 VPWR VGND sg13g2_decap_8
XFILLER_1_665 VPWR VGND sg13g2_decap_8
XFILLER_49_636 VPWR VGND sg13g2_decap_8
XFILLER_0_186 VPWR VGND sg13g2_decap_8
XFILLER_29_360 VPWR VGND sg13g2_decap_4
XFILLER_45_842 VPWR VGND sg13g2_decap_8
XFILLER_44_352 VPWR VGND sg13g2_fill_1
XFILLER_8_220 VPWR VGND sg13g2_decap_8
XFILLER_9_721 VPWR VGND sg13g2_decap_8
XFILLER_13_772 VPWR VGND sg13g2_decap_8
X_2660_ _1000_ net355 net375 VPWR VGND sg13g2_nand2_2
XFILLER_8_297 VPWR VGND sg13g2_decap_8
XFILLER_9_798 VPWR VGND sg13g2_decap_8
X_1611_ net315 VPWR _1295_ VGND _0960_ _1046_ sg13g2_o21ai_1
X_2591_ net400 VPWR _0940_ VGND net237 net309 sg13g2_o21ai_1
XFILLER_5_982 VPWR VGND sg13g2_decap_8
X_1542_ VPWR VGND _1115_ _1226_ _1218_ _1043_ _1227_ _1216_ sg13g2_a221oi_1
XFILLER_5_86 VPWR VGND sg13g2_decap_8
X_2931__116 VPWR VGND net116 sg13g2_tiehi
XFILLER_36_820 VPWR VGND sg13g2_decap_8
XFILLER_36_831 VPWR VGND sg13g2_fill_2
X_2025_ VGND VPWR _0484_ _0500_ _0485_ _0442_ sg13g2_a21oi_2
XFILLER_36_875 VPWR VGND sg13g2_fill_1
XFILLER_23_547 VPWR VGND sg13g2_decap_8
XFILLER_10_219 VPWR VGND sg13g2_fill_2
XFILLER_10_208 VPWR VGND sg13g2_decap_8
X_2927_ net124 VGND VPWR _0084_ falutop.i2c_inst.result\[5\] clknet_4_12_0_clk sg13g2_dfrbpq_1
XFILLER_40_28 VPWR VGND sg13g2_decap_8
X_2858_ net80 VGND VPWR _0015_ falutop.div_inst.acc\[8\] clknet_4_8_0_clk sg13g2_dfrbpq_1
X_2789_ _0976_ _1127_ _1128_ VPWR VGND sg13g2_nor2_1
X_1809_ VGND VPWR _0193_ _0219_ _0289_ _0218_ sg13g2_a21oi_1
XFILLER_39_680 VPWR VGND sg13g2_fill_1
XFILLER_18_319 VPWR VGND sg13g2_decap_8
XFILLER_42_823 VPWR VGND sg13g2_decap_8
XFILLER_27_875 VPWR VGND sg13g2_decap_8
XFILLER_41_333 VPWR VGND sg13g2_decap_8
XFILLER_41_311 VPWR VGND sg13g2_decap_4
X_2843__121 VPWR VGND net121 sg13g2_tiehi
XFILLER_22_591 VPWR VGND sg13g2_decap_8
XFILLER_6_713 VPWR VGND sg13g2_decap_8
XFILLER_10_764 VPWR VGND sg13g2_decap_8
XFILLER_5_267 VPWR VGND sg13g2_fill_1
XFILLER_2_952 VPWR VGND sg13g2_decap_8
XFILLER_49_400 VPWR VGND sg13g2_decap_8
XFILLER_1_462 VPWR VGND sg13g2_decap_8
XFILLER_36_105 VPWR VGND sg13g2_decap_8
XFILLER_18_842 VPWR VGND sg13g2_decap_8
XFILLER_44_193 VPWR VGND sg13g2_fill_1
XFILLER_20_528 VPWR VGND sg13g2_decap_4
XFILLER_13_591 VPWR VGND sg13g2_decap_8
X_2712_ net380 _1050_ _1052_ VPWR VGND sg13g2_and2_1
XFILLER_9_595 VPWR VGND sg13g2_decap_8
X_2643_ _0951_ _0982_ _0983_ VPWR VGND sg13g2_nor2_1
X_2574_ net253 net240 _0773_ _0061_ VPWR VGND sg13g2_mux2_1
X_1525_ _1208_ _1205_ _1210_ VPWR VGND sg13g2_xor2_1
XFILLER_27_105 VPWR VGND sg13g2_decap_8
X_2008_ VPWR _0484_ _0483_ VGND sg13g2_inv_1
XFILLER_23_311 VPWR VGND sg13g2_fill_1
XFILLER_24_856 VPWR VGND sg13g2_decap_4
XFILLER_13_1017 VPWR VGND sg13g2_decap_8
XFILLER_13_1028 VPWR VGND sg13g2_fill_1
XFILLER_2_237 VPWR VGND sg13g2_fill_2
XFILLER_19_606 VPWR VGND sg13g2_decap_8
XFILLER_19_628 VPWR VGND sg13g2_fill_1
X_2984__109 VPWR VGND net109 sg13g2_tiehi
XFILLER_47_959 VPWR VGND sg13g2_decap_8
XFILLER_18_138 VPWR VGND sg13g2_decap_8
XFILLER_26_160 VPWR VGND sg13g2_decap_8
XFILLER_27_694 VPWR VGND sg13g2_decap_8
XFILLER_15_856 VPWR VGND sg13g2_decap_8
XFILLER_42_675 VPWR VGND sg13g2_decap_8
XFILLER_41_174 VPWR VGND sg13g2_decap_8
XFILLER_14_366 VPWR VGND sg13g2_fill_2
XFILLER_14_377 VPWR VGND sg13g2_decap_8
XFILLER_14_388 VPWR VGND sg13g2_fill_2
XFILLER_6_510 VPWR VGND sg13g2_decap_8
XFILLER_10_561 VPWR VGND sg13g2_decap_8
XFILLER_6_587 VPWR VGND sg13g2_decap_8
XFILLER_44_7 VPWR VGND sg13g2_fill_2
X_2290_ _0716_ falutop.i2c_inst.counter\[2\] _0706_ VPWR VGND sg13g2_nand2_2
XFILLER_49_230 VPWR VGND sg13g2_decap_8
XFILLER_38_904 VPWR VGND sg13g2_decap_8
XFILLER_2_32 VPWR VGND sg13g2_decap_8
XFILLER_49_285 VPWR VGND sg13g2_decap_8
XFILLER_37_458 VPWR VGND sg13g2_fill_2
XFILLER_46_981 VPWR VGND sg13g2_decap_8
XFILLER_45_491 VPWR VGND sg13g2_fill_1
XFILLER_45_480 VPWR VGND sg13g2_decap_8
XFILLER_33_653 VPWR VGND sg13g2_decap_8
XFILLER_36_1028 VPWR VGND sg13g2_fill_1
XFILLER_20_303 VPWR VGND sg13g2_fill_1
XFILLER_32_163 VPWR VGND sg13g2_decap_8
XFILLER_21_848 VPWR VGND sg13g2_decap_8
XFILLER_21_859 VPWR VGND sg13g2_fill_2
XFILLER_32_196 VPWR VGND sg13g2_decap_8
X_2626_ _0963_ _0965_ _0966_ VPWR VGND sg13g2_nor2_2
X_2557_ net216 falutop.div_inst.busy _0925_ VPWR VGND sg13g2_and2_1
XFILLER_0_708 VPWR VGND sg13g2_decap_8
X_2488_ _0869_ _0882_ _0883_ _0884_ VPWR VGND sg13g2_nor3_1
X_2879__51 VPWR VGND net51 sg13g2_tiehi
X_1508_ VGND VPWR _1194_ _1193_ net224 sg13g2_or2_1
XFILLER_28_414 VPWR VGND sg13g2_fill_2
XFILLER_29_937 VPWR VGND sg13g2_decap_8
XFILLER_44_907 VPWR VGND sg13g2_decap_8
XFILLER_43_417 VPWR VGND sg13g2_decap_8
XFILLER_28_469 VPWR VGND sg13g2_decap_8
XFILLER_37_992 VPWR VGND sg13g2_decap_8
XFILLER_11_30 VPWR VGND sg13g2_fill_1
XFILLER_3_557 VPWR VGND sg13g2_decap_8
Xfanout393 net394 net393 VPWR VGND sg13g2_buf_8
Xfanout382 falutop.data_in\[15\] net382 VPWR VGND sg13g2_buf_8
Xfanout371 net424 net371 VPWR VGND sg13g2_buf_8
Xfanout360 net362 net360 VPWR VGND sg13g2_buf_8
XFILLER_47_756 VPWR VGND sg13g2_decap_8
XFILLER_46_222 VPWR VGND sg13g2_decap_8
XFILLER_34_406 VPWR VGND sg13g2_decap_8
XFILLER_36_82 VPWR VGND sg13g2_decap_4
XFILLER_43_962 VPWR VGND sg13g2_decap_8
XFILLER_15_631 VPWR VGND sg13g2_fill_2
XFILLER_27_491 VPWR VGND sg13g2_decap_4
XFILLER_14_152 VPWR VGND sg13g2_fill_2
XFILLER_15_697 VPWR VGND sg13g2_decap_8
XFILLER_30_601 VPWR VGND sg13g2_decap_8
X_1790_ _0270_ _0198_ _0269_ VPWR VGND sg13g2_xnor2_1
XFILLER_30_678 VPWR VGND sg13g2_decap_8
XFILLER_7_863 VPWR VGND sg13g2_decap_8
XFILLER_6_395 VPWR VGND sg13g2_fill_2
X_2411_ _0802_ _0821_ _0822_ VPWR VGND sg13g2_nor2_1
X_2342_ net358 _0761_ VPWR VGND sg13g2_inv_4
X_2273_ _0685_ _0697_ _0704_ VPWR VGND sg13g2_nor2_1
X_2876__54 VPWR VGND net54 sg13g2_tiehi
XFILLER_37_233 VPWR VGND sg13g2_decap_8
XFILLER_37_277 VPWR VGND sg13g2_decap_4
XFILLER_40_409 VPWR VGND sg13g2_fill_2
XFILLER_21_656 VPWR VGND sg13g2_decap_8
XFILLER_21_678 VPWR VGND sg13g2_decap_4
X_1988_ _0464_ net332 _1329_ VPWR VGND sg13g2_nand2_1
XFILLER_20_177 VPWR VGND sg13g2_fill_1
XFILLER_10_1009 VPWR VGND sg13g2_decap_8
X_2609_ _0949_ net331 _0760_ VPWR VGND sg13g2_nand2_1
XFILLER_0_505 VPWR VGND sg13g2_decap_8
Xclkbuf_4_5_0_clk clknet_0_clk clknet_4_5_0_clk VPWR VGND sg13g2_buf_8
XFILLER_16_417 VPWR VGND sg13g2_fill_1
XFILLER_25_973 VPWR VGND sg13g2_decap_8
XFILLER_40_954 VPWR VGND sg13g2_decap_8
XFILLER_8_627 VPWR VGND sg13g2_decap_8
XFILLER_7_137 VPWR VGND sg13g2_fill_1
XFILLER_4_811 VPWR VGND sg13g2_decap_8
XFILLER_22_84 VPWR VGND sg13g2_decap_8
XFILLER_4_888 VPWR VGND sg13g2_decap_8
XFILLER_3_376 VPWR VGND sg13g2_decap_4
XFILLER_0_0 VPWR VGND sg13g2_decap_8
XFILLER_47_531 VPWR VGND sg13g2_decap_8
XFILLER_19_211 VPWR VGND sg13g2_decap_8
XFILLER_47_564 VPWR VGND sg13g2_fill_1
XFILLER_19_288 VPWR VGND sg13g2_decap_8
X_2873__57 VPWR VGND net57 sg13g2_tiehi
XFILLER_35_737 VPWR VGND sg13g2_decap_8
XFILLER_34_247 VPWR VGND sg13g2_decap_8
X_2960_ net159 VGND VPWR _0117_ falutop.div_inst.b\[4\] clknet_4_3_0_clk sg13g2_dfrbpq_1
XFILLER_16_995 VPWR VGND sg13g2_decap_8
X_2891_ net37 VGND VPWR _0048_ falutop.alu_inst.op\[1\] clknet_4_14_0_clk sg13g2_dfrbpq_2
X_1911_ _0388_ _0376_ _0389_ VPWR VGND sg13g2_nor2b_1
X_1842_ _0287_ VPWR _0321_ VGND _0259_ _0285_ sg13g2_o21ai_1
XFILLER_31_976 VPWR VGND sg13g2_decap_8
XFILLER_33_1009 VPWR VGND sg13g2_decap_8
XFILLER_30_475 VPWR VGND sg13g2_decap_8
XFILLER_7_660 VPWR VGND sg13g2_decap_8
X_1773_ _0238_ _0240_ _0225_ _0254_ VPWR VGND _0253_ sg13g2_nand4_1
X_2951__61 VPWR VGND net61 sg13g2_tiehi
XFILLER_33_0 VPWR VGND sg13g2_decap_4
X_2325_ _0744_ falutop.i2c_inst.op\[0\] VPWR VGND sg13g2_inv_2
X_2256_ _0692_ _0868_ _0882_ VPWR VGND sg13g2_nand2_2
X_2187_ falutop.data_in\[12\] net295 _0644_ VPWR VGND sg13g2_nor2_1
XFILLER_43_28 VPWR VGND sg13g2_decap_8
XFILLER_40_206 VPWR VGND sg13g2_decap_8
XFILLER_22_921 VPWR VGND sg13g2_decap_8
XFILLER_40_239 VPWR VGND sg13g2_decap_8
XFILLER_21_420 VPWR VGND sg13g2_decap_8
XFILLER_34_781 VPWR VGND sg13g2_decap_8
XFILLER_21_464 VPWR VGND sg13g2_fill_1
XFILLER_22_998 VPWR VGND sg13g2_decap_8
XFILLER_1_847 VPWR VGND sg13g2_decap_8
X_2942__83 VPWR VGND net83 sg13g2_tiehi
XFILLER_49_818 VPWR VGND sg13g2_decap_8
XFILLER_0_379 VPWR VGND sg13g2_decap_8
XFILLER_29_531 VPWR VGND sg13g2_decap_8
XFILLER_29_564 VPWR VGND sg13g2_decap_8
XFILLER_16_236 VPWR VGND sg13g2_decap_4
XFILLER_31_217 VPWR VGND sg13g2_decap_8
XFILLER_9_903 VPWR VGND sg13g2_decap_8
XFILLER_13_954 VPWR VGND sg13g2_decap_8
XFILLER_25_781 VPWR VGND sg13g2_decap_4
XFILLER_40_740 VPWR VGND sg13g2_fill_1
XFILLER_33_50 VPWR VGND sg13g2_decap_8
XFILLER_40_795 VPWR VGND sg13g2_decap_8
XFILLER_4_685 VPWR VGND sg13g2_decap_8
XFILLER_3_151 VPWR VGND sg13g2_fill_1
XFILLER_39_317 VPWR VGND sg13g2_decap_8
X_2110_ _0557_ _0559_ _0583_ VPWR VGND sg13g2_nor2_1
Xhold2 falutop.div_inst.a\[2\] VPWR VGND net176 sg13g2_dlygate4sd3_1
X_2041_ _0516_ _0511_ _0515_ VPWR VGND sg13g2_nand2_1
XFILLER_47_350 VPWR VGND sg13g2_fill_2
XFILLER_35_534 VPWR VGND sg13g2_fill_1
XFILLER_16_770 VPWR VGND sg13g2_decap_4
X_2943_ net81 VGND VPWR _0100_ falutop.alu_data_in\[3\] clknet_4_10_0_clk sg13g2_dfrbpq_2
X_2874_ net56 VGND VPWR _0031_ falutop.data_in\[3\] net395 sg13g2_dfrbpq_2
XFILLER_30_261 VPWR VGND sg13g2_decap_8
XFILLER_31_795 VPWR VGND sg13g2_fill_2
X_1825_ _0303_ VPWR _0305_ VGND _0983_ _0304_ sg13g2_o21ai_1
XFILLER_8_991 VPWR VGND sg13g2_decap_8
X_1756_ _0237_ _0226_ _0235_ VPWR VGND sg13g2_nand2_1
X_1687_ _0166_ _0167_ _0168_ _0169_ VPWR VGND sg13g2_nor3_1
X_2308_ VGND VPWR net391 _0727_ _0145_ _0728_ sg13g2_a21oi_1
XFILLER_38_28 VPWR VGND sg13g2_decap_8
X_2239_ _0678_ falutop.data_in\[13\] _0680_ VPWR VGND sg13g2_xor2_1
XFILLER_26_567 VPWR VGND sg13g2_decap_8
XFILLER_13_217 VPWR VGND sg13g2_decap_8
XFILLER_10_946 VPWR VGND sg13g2_decap_8
XFILLER_21_283 VPWR VGND sg13g2_decap_8
XFILLER_5_427 VPWR VGND sg13g2_decap_4
XFILLER_1_644 VPWR VGND sg13g2_decap_8
XFILLER_49_604 VPWR VGND sg13g2_decap_8
XFILLER_0_154 VPWR VGND sg13g2_decap_8
XFILLER_45_821 VPWR VGND sg13g2_decap_8
XFILLER_17_556 VPWR VGND sg13g2_fill_1
XFILLER_45_898 VPWR VGND sg13g2_decap_8
XFILLER_44_71 VPWR VGND sg13g2_fill_1
XFILLER_44_60 VPWR VGND sg13g2_decap_8
XFILLER_32_526 VPWR VGND sg13g2_fill_1
XFILLER_9_700 VPWR VGND sg13g2_decap_8
XFILLER_13_751 VPWR VGND sg13g2_decap_8
XFILLER_9_777 VPWR VGND sg13g2_decap_8
XFILLER_12_283 VPWR VGND sg13g2_decap_8
X_1610_ _1051_ _1071_ _0958_ _1294_ VPWR VGND sg13g2_mux2_1
X_2590_ VGND VPWR _0734_ net310 _0069_ _0939_ sg13g2_a21oi_1
XFILLER_5_961 VPWR VGND sg13g2_decap_8
XFILLER_5_32 VPWR VGND sg13g2_decap_8
X_1541_ _1222_ _1224_ _1220_ _1226_ VPWR VGND _1225_ sg13g2_nand4_1
XFILLER_5_65 VPWR VGND sg13g2_decap_8
XFILLER_4_482 VPWR VGND sg13g2_decap_8
XFILLER_39_125 VPWR VGND sg13g2_fill_1
XFILLER_39_147 VPWR VGND sg13g2_fill_2
XFILLER_39_136 VPWR VGND sg13g2_decap_4
X_2024_ VPWR VGND _0498_ _0446_ _0485_ _0320_ _0499_ _0401_ sg13g2_a221oi_1
XFILLER_36_854 VPWR VGND sg13g2_fill_1
XFILLER_39_1015 VPWR VGND sg13g2_decap_8
XFILLER_23_504 VPWR VGND sg13g2_decap_8
XFILLER_35_353 VPWR VGND sg13g2_fill_1
X_2926_ net126 VGND VPWR _0083_ falutop.i2c_inst.result\[4\] clknet_4_7_0_clk sg13g2_dfrbpq_1
X_2857_ net82 VGND VPWR net187 falutop.div_inst.acc\[7\] clknet_4_8_0_clk sg13g2_dfrbpq_2
X_1808_ _0288_ _0258_ _0286_ VPWR VGND sg13g2_xnor2_1
X_2788_ _1127_ net378 _1041_ VPWR VGND sg13g2_nand2_1
X_1739_ _0220_ _0192_ _0219_ VPWR VGND sg13g2_xnor2_1
XFILLER_49_49 VPWR VGND sg13g2_decap_8
XFILLER_45_106 VPWR VGND sg13g2_fill_1
XFILLER_27_810 VPWR VGND sg13g2_fill_1
XFILLER_38_180 VPWR VGND sg13g2_decap_4
XFILLER_27_843 VPWR VGND sg13g2_fill_2
XFILLER_42_802 VPWR VGND sg13g2_decap_8
XFILLER_14_526 VPWR VGND sg13g2_fill_2
XFILLER_42_879 VPWR VGND sg13g2_decap_8
XFILLER_22_570 VPWR VGND sg13g2_decap_8
XFILLER_10_743 VPWR VGND sg13g2_decap_8
XFILLER_14_74 VPWR VGND sg13g2_decap_8
XFILLER_5_213 VPWR VGND sg13g2_decap_8
XFILLER_6_769 VPWR VGND sg13g2_decap_8
XFILLER_5_279 VPWR VGND sg13g2_decap_8
XFILLER_30_51 VPWR VGND sg13g2_decap_8
XFILLER_30_62 VPWR VGND sg13g2_fill_1
XFILLER_2_931 VPWR VGND sg13g2_decap_8
XFILLER_1_441 VPWR VGND sg13g2_decap_8
XFILLER_7_1024 VPWR VGND sg13g2_decap_4
XFILLER_49_467 VPWR VGND sg13g2_decap_8
XFILLER_49_478 VPWR VGND sg13g2_fill_2
XFILLER_18_821 VPWR VGND sg13g2_decap_8
XFILLER_17_353 VPWR VGND sg13g2_decap_8
XFILLER_33_802 VPWR VGND sg13g2_decap_8
XFILLER_18_898 VPWR VGND sg13g2_decap_8
XFILLER_33_868 VPWR VGND sg13g2_fill_2
XFILLER_13_570 VPWR VGND sg13g2_decap_8
X_2711_ _1042_ _1049_ _1051_ VPWR VGND sg13g2_nor2_2
XFILLER_9_574 VPWR VGND sg13g2_decap_8
X_2642_ VGND VPWR _0752_ net362 _0982_ _0981_ sg13g2_a21oi_1
X_2573_ net245 net185 _0773_ _0060_ VPWR VGND sg13g2_mux2_1
X_1524_ _1209_ _1205_ _1208_ VPWR VGND sg13g2_nand2_1
XFILLER_4_290 VPWR VGND sg13g2_fill_1
XFILLER_19_19 VPWR VGND sg13g2_decap_8
XFILLER_28_607 VPWR VGND sg13g2_fill_2
XFILLER_42_109 VPWR VGND sg13g2_decap_4
X_2007_ _0440_ _0438_ _0482_ _0483_ VPWR VGND sg13g2_a21o_1
XFILLER_24_813 VPWR VGND sg13g2_decap_8
XFILLER_24_824 VPWR VGND sg13g2_fill_2
XFILLER_35_183 VPWR VGND sg13g2_decap_8
XFILLER_23_367 VPWR VGND sg13g2_fill_2
XFILLER_23_389 VPWR VGND sg13g2_decap_8
XFILLER_32_890 VPWR VGND sg13g2_decap_8
X_2909_ net160 VGND VPWR _0066_ falutop.div_inst.val\[3\] clknet_4_7_0_clk sg13g2_dfrbpq_2
XFILLER_3_739 VPWR VGND sg13g2_decap_8
XFILLER_2_216 VPWR VGND sg13g2_fill_2
XFILLER_47_938 VPWR VGND sg13g2_decap_8
XFILLER_46_448 VPWR VGND sg13g2_fill_2
XFILLER_46_437 VPWR VGND sg13g2_decap_8
XFILLER_18_117 VPWR VGND sg13g2_decap_8
XFILLER_15_835 VPWR VGND sg13g2_decap_8
XFILLER_42_643 VPWR VGND sg13g2_decap_8
XFILLER_23_890 VPWR VGND sg13g2_decap_8
XFILLER_10_540 VPWR VGND sg13g2_decap_8
XFILLER_6_566 VPWR VGND sg13g2_decap_8
XFILLER_29_1014 VPWR VGND sg13g2_decap_8
XFILLER_37_7 VPWR VGND sg13g2_decap_8
X_2888__41 VPWR VGND net41 sg13g2_tiehi
XFILLER_2_11 VPWR VGND sg13g2_decap_8
XFILLER_37_437 VPWR VGND sg13g2_decap_8
XFILLER_2_99 VPWR VGND sg13g2_decap_4
XFILLER_46_960 VPWR VGND sg13g2_decap_8
XFILLER_18_684 VPWR VGND sg13g2_fill_1
XFILLER_36_1007 VPWR VGND sg13g2_decap_8
XFILLER_33_632 VPWR VGND sg13g2_decap_8
XFILLER_21_827 VPWR VGND sg13g2_decap_8
XFILLER_32_142 VPWR VGND sg13g2_decap_8
X_2625_ net345 net368 _0965_ VPWR VGND sg13g2_nor2_1
X_2556_ _0050_ _0758_ net296 net409 _0745_ VPWR VGND sg13g2_a22oi_1
X_2487_ falutop.i2c_inst.counter\[1\] _0742_ _0883_ VPWR VGND sg13g2_nor2_2
X_1507_ _1193_ _1135_ _1192_ VPWR VGND sg13g2_nand2_1
XFILLER_29_916 VPWR VGND sg13g2_decap_8
XFILLER_46_28 VPWR VGND sg13g2_decap_8
XFILLER_28_437 VPWR VGND sg13g2_decap_8
XFILLER_37_971 VPWR VGND sg13g2_decap_8
XFILLER_23_120 VPWR VGND sg13g2_decap_4
XFILLER_24_654 VPWR VGND sg13g2_decap_8
XFILLER_23_142 VPWR VGND sg13g2_decap_8
XFILLER_24_676 VPWR VGND sg13g2_fill_1
XFILLER_8_809 VPWR VGND sg13g2_decap_8
XFILLER_12_849 VPWR VGND sg13g2_decap_8
XFILLER_7_308 VPWR VGND sg13g2_fill_1
XFILLER_11_20 VPWR VGND sg13g2_fill_1
XFILLER_3_536 VPWR VGND sg13g2_decap_8
XFILLER_2_4 VPWR VGND sg13g2_decap_8
Xfanout350 falutop.alu_data_in\[9\] net350 VPWR VGND sg13g2_buf_8
Xfanout383 falutop.data_in\[15\] net383 VPWR VGND sg13g2_buf_8
Xfanout372 net374 net372 VPWR VGND sg13g2_buf_8
Xfanout361 net362 net361 VPWR VGND sg13g2_buf_1
XFILLER_47_735 VPWR VGND sg13g2_decap_8
Xfanout394 net399 net394 VPWR VGND sg13g2_buf_8
XFILLER_19_448 VPWR VGND sg13g2_decap_8
XFILLER_46_267 VPWR VGND sg13g2_decap_8
XFILLER_27_470 VPWR VGND sg13g2_decap_8
XFILLER_28_993 VPWR VGND sg13g2_decap_8
XFILLER_36_72 VPWR VGND sg13g2_decap_4
XFILLER_43_941 VPWR VGND sg13g2_decap_8
XFILLER_15_654 VPWR VGND sg13g2_decap_8
XFILLER_14_164 VPWR VGND sg13g2_decap_8
XFILLER_14_197 VPWR VGND sg13g2_fill_1
XFILLER_30_646 VPWR VGND sg13g2_decap_4
XFILLER_30_657 VPWR VGND sg13g2_fill_2
XFILLER_30_668 VPWR VGND sg13g2_fill_2
XFILLER_7_842 VPWR VGND sg13g2_decap_8
XFILLER_10_381 VPWR VGND sg13g2_fill_2
XFILLER_6_341 VPWR VGND sg13g2_decap_8
X_2410_ VGND VPWR _0819_ _0820_ _0821_ _0803_ sg13g2_a21oi_1
X_2341_ net357 _0760_ VPWR VGND sg13g2_inv_4
X_2272_ VGND VPWR _0731_ _0702_ _0134_ _0703_ sg13g2_a21oi_1
XFILLER_37_256 VPWR VGND sg13g2_decap_8
XFILLER_19_982 VPWR VGND sg13g2_decap_8
XFILLER_18_492 VPWR VGND sg13g2_decap_4
XFILLER_21_602 VPWR VGND sg13g2_fill_2
XFILLER_34_985 VPWR VGND sg13g2_decap_8
XFILLER_20_134 VPWR VGND sg13g2_fill_2
X_1987_ _0463_ net360 net332 net364 net329 VPWR VGND sg13g2_a22oi_1
X_2608_ VGND VPWR _0853_ net312 _0078_ _0948_ sg13g2_a21oi_1
X_2539_ _0914_ _0882_ falutop.i2c_inst.result\[13\] _0872_ falutop.i2c_inst.result\[15\]
+ VPWR VGND sg13g2_a22oi_1
XFILLER_29_713 VPWR VGND sg13g2_decap_8
X_2867__66 VPWR VGND net66 sg13g2_tiehi
XFILLER_28_223 VPWR VGND sg13g2_fill_1
XFILLER_28_212 VPWR VGND sg13g2_decap_8
XFILLER_44_705 VPWR VGND sg13g2_decap_8
XFILLER_17_919 VPWR VGND sg13g2_decap_8
XFILLER_43_215 VPWR VGND sg13g2_decap_8
XFILLER_43_259 VPWR VGND sg13g2_decap_8
XFILLER_43_226 VPWR VGND sg13g2_fill_1
XFILLER_37_790 VPWR VGND sg13g2_decap_8
XFILLER_25_952 VPWR VGND sg13g2_decap_8
XFILLER_12_613 VPWR VGND sg13g2_fill_1
XFILLER_19_1024 VPWR VGND sg13g2_decap_4
XFILLER_24_462 VPWR VGND sg13g2_decap_4
XFILLER_40_933 VPWR VGND sg13g2_decap_8
XFILLER_12_624 VPWR VGND sg13g2_decap_8
XFILLER_8_606 VPWR VGND sg13g2_decap_8
XFILLER_22_30 VPWR VGND sg13g2_fill_2
XFILLER_4_867 VPWR VGND sg13g2_decap_8
XFILLER_3_366 VPWR VGND sg13g2_fill_1
XFILLER_3_355 VPWR VGND sg13g2_decap_8
XFILLER_19_256 VPWR VGND sg13g2_fill_1
XFILLER_47_576 VPWR VGND sg13g2_decap_8
XFILLER_47_93 VPWR VGND sg13g2_decap_8
XFILLER_35_716 VPWR VGND sg13g2_decap_8
XFILLER_15_440 VPWR VGND sg13g2_fill_1
XFILLER_16_974 VPWR VGND sg13g2_decap_8
X_2890_ net38 VGND VPWR _0047_ falutop.alu_inst.op\[0\] clknet_4_15_0_clk sg13g2_dfrbpq_2
X_1910_ _0388_ _0379_ _0387_ VPWR VGND sg13g2_xnor2_1
XFILLER_15_495 VPWR VGND sg13g2_fill_1
XFILLER_31_955 VPWR VGND sg13g2_decap_8
X_1841_ _0290_ VPWR _0320_ VGND _0291_ _0292_ sg13g2_o21ai_1
XFILLER_8_76 VPWR VGND sg13g2_decap_8
X_1772_ VPWR VGND _1115_ _0252_ _0244_ _1043_ _0253_ _0241_ sg13g2_a221oi_1
XFILLER_6_171 VPWR VGND sg13g2_decap_8
X_2324_ VPWR _0743_ falutop.i2c_inst.state\[1\] VGND sg13g2_inv_1
X_2255_ VGND VPWR net390 _0690_ _0129_ _0691_ sg13g2_a21oi_1
XFILLER_38_543 VPWR VGND sg13g2_fill_2
X_2186_ VGND VPWR net325 net298 _0108_ _0643_ sg13g2_a21oi_1
XFILLER_38_587 VPWR VGND sg13g2_decap_8
XFILLER_26_716 VPWR VGND sg13g2_decap_4
XFILLER_19_790 VPWR VGND sg13g2_decap_8
XFILLER_22_900 VPWR VGND sg13g2_decap_8
XFILLER_21_454 VPWR VGND sg13g2_decap_4
XFILLER_22_977 VPWR VGND sg13g2_decap_8
XFILLER_21_498 VPWR VGND sg13g2_fill_1
XFILLER_4_108 VPWR VGND sg13g2_fill_2
XFILLER_49_1028 VPWR VGND sg13g2_fill_1
XFILLER_1_826 VPWR VGND sg13g2_decap_8
XFILLER_0_358 VPWR VGND sg13g2_decap_8
XFILLER_44_502 VPWR VGND sg13g2_decap_8
XFILLER_1_1008 VPWR VGND sg13g2_decap_8
XFILLER_16_204 VPWR VGND sg13g2_decap_8
XFILLER_44_579 VPWR VGND sg13g2_decap_8
XFILLER_13_933 VPWR VGND sg13g2_decap_8
XFILLER_40_774 VPWR VGND sg13g2_decap_8
XFILLER_8_425 VPWR VGND sg13g2_fill_2
XFILLER_9_959 VPWR VGND sg13g2_decap_8
XFILLER_12_498 VPWR VGND sg13g2_decap_8
XFILLER_4_664 VPWR VGND sg13g2_decap_8
Xhold3 falutop.i2c_inst.result\[1\] VPWR VGND net177 sg13g2_dlygate4sd3_1
X_2040_ _0515_ _0246_ _0513_ VPWR VGND sg13g2_xnor2_1
XFILLER_48_885 VPWR VGND sg13g2_decap_8
XFILLER_47_373 VPWR VGND sg13g2_fill_1
X_2942_ net83 VGND VPWR _0099_ falutop.alu_data_in\[2\] clknet_4_11_0_clk sg13g2_dfrbpq_1
XFILLER_22_218 VPWR VGND sg13g2_fill_1
XFILLER_31_752 VPWR VGND sg13g2_decap_8
X_2873_ net57 VGND VPWR _0030_ falutop.data_in\[2\] net395 sg13g2_dfrbpq_2
XFILLER_30_273 VPWR VGND sg13g2_decap_8
XFILLER_31_785 VPWR VGND sg13g2_decap_4
Xclkbuf_4_4_0_clk clknet_0_clk clknet_4_4_0_clk VPWR VGND sg13g2_buf_8
X_1824_ _0304_ _0950_ _0989_ VPWR VGND sg13g2_nand2_1
XFILLER_8_970 VPWR VGND sg13g2_decap_8
X_1755_ VGND VPWR _0236_ _0235_ _0226_ sg13g2_or2_1
X_1686_ VGND VPWR _1204_ _1313_ _0168_ _1312_ sg13g2_a21oi_1
X_2307_ net408 VPWR _0728_ VGND falutop.i2c_inst.data_in\[17\] _0727_ sg13g2_o21ai_1
XFILLER_39_841 VPWR VGND sg13g2_decap_4
X_2238_ net200 net301 _0679_ VPWR VGND sg13g2_nor2_1
XFILLER_39_896 VPWR VGND sg13g2_decap_8
X_2169_ falutop.data_in\[2\] net371 net295 _0099_ VPWR VGND sg13g2_mux2_1
XFILLER_26_546 VPWR VGND sg13g2_decap_8
XFILLER_16_1016 VPWR VGND sg13g2_decap_8
XFILLER_10_925 VPWR VGND sg13g2_decap_8
XFILLER_16_1027 VPWR VGND sg13g2_fill_2
XFILLER_22_785 VPWR VGND sg13g2_decap_8
XFILLER_22_796 VPWR VGND sg13g2_fill_2
XFILLER_5_406 VPWR VGND sg13g2_decap_8
XFILLER_1_623 VPWR VGND sg13g2_decap_8
XFILLER_0_133 VPWR VGND sg13g2_fill_2
XFILLER_23_1009 VPWR VGND sg13g2_decap_8
XFILLER_45_800 VPWR VGND sg13g2_decap_8
XFILLER_17_513 VPWR VGND sg13g2_decap_8
XFILLER_28_84 VPWR VGND sg13g2_decap_8
XFILLER_45_877 VPWR VGND sg13g2_decap_8
XFILLER_44_398 VPWR VGND sg13g2_decap_4
XFILLER_44_83 VPWR VGND sg13g2_decap_8
X_2851__94 VPWR VGND net94 sg13g2_tiehi
XFILLER_12_262 VPWR VGND sg13g2_decap_8
XFILLER_8_244 VPWR VGND sg13g2_fill_2
XFILLER_9_756 VPWR VGND sg13g2_decap_8
XFILLER_5_940 VPWR VGND sg13g2_decap_8
XFILLER_5_11 VPWR VGND sg13g2_decap_8
X_1540_ VGND VPWR _0964_ _1051_ _1225_ _1223_ sg13g2_a21oi_1
XFILLER_5_44 VPWR VGND sg13g2_decap_8
XFILLER_4_461 VPWR VGND sg13g2_decap_8
XFILLER_47_181 VPWR VGND sg13g2_fill_2
X_2023_ _0498_ _0483_ _0444_ VPWR VGND sg13g2_nand2b_1
XFILLER_36_888 VPWR VGND sg13g2_decap_8
XFILLER_23_527 VPWR VGND sg13g2_fill_2
XFILLER_16_590 VPWR VGND sg13g2_decap_8
X_2925_ net128 VGND VPWR _0082_ falutop.i2c_inst.result\[3\] clknet_4_12_0_clk sg13g2_dfrbpq_1
X_2856_ net84 VGND VPWR net208 falutop.div_inst.acc\[6\] clknet_4_11_0_clk sg13g2_dfrbpq_2
X_1807_ _0287_ _0258_ _0286_ VPWR VGND sg13g2_nand2_1
X_2787_ net378 _1041_ _1126_ VPWR VGND sg13g2_and2_1
X_1738_ _0217_ _0194_ _0219_ VPWR VGND sg13g2_xor2_1
XFILLER_49_28 VPWR VGND sg13g2_decap_8
XFILLER_46_1009 VPWR VGND sg13g2_decap_8
X_1669_ _0151_ net337 net376 VPWR VGND sg13g2_nand2_1
XFILLER_27_822 VPWR VGND sg13g2_decap_8
XFILLER_42_858 VPWR VGND sg13g2_decap_8
XFILLER_41_357 VPWR VGND sg13g2_decap_4
XFILLER_14_53 VPWR VGND sg13g2_decap_8
XFILLER_10_722 VPWR VGND sg13g2_decap_8
XFILLER_6_748 VPWR VGND sg13g2_decap_8
XFILLER_10_799 VPWR VGND sg13g2_decap_8
XFILLER_5_258 VPWR VGND sg13g2_decap_8
XFILLER_2_910 VPWR VGND sg13g2_decap_8
XFILLER_1_420 VPWR VGND sg13g2_decap_8
XFILLER_7_1003 VPWR VGND sg13g2_decap_8
XFILLER_2_987 VPWR VGND sg13g2_decap_8
XFILLER_49_446 VPWR VGND sg13g2_decap_8
XFILLER_39_83 VPWR VGND sg13g2_decap_8
XFILLER_1_497 VPWR VGND sg13g2_decap_8
XFILLER_17_310 VPWR VGND sg13g2_decap_8
XFILLER_45_641 VPWR VGND sg13g2_fill_1
XFILLER_18_877 VPWR VGND sg13g2_decap_8
XFILLER_29_192 VPWR VGND sg13g2_decap_8
XFILLER_44_151 VPWR VGND sg13g2_decap_8
XFILLER_41_891 VPWR VGND sg13g2_decap_8
X_2710_ _0757_ falutop.alu_inst.op\[3\] _1050_ VPWR VGND sg13g2_nor2_1
XFILLER_9_553 VPWR VGND sg13g2_decap_8
X_2641_ VGND VPWR _0957_ _0980_ _0981_ _0955_ sg13g2_a21oi_1
X_2572_ net254 net225 _0773_ _0059_ VPWR VGND sg13g2_mux2_1
X_1523_ VGND VPWR _0963_ _0999_ _1208_ _1207_ sg13g2_a21oi_1
XFILLER_28_619 VPWR VGND sg13g2_decap_8
X_2006_ _0480_ _0416_ _0482_ VPWR VGND sg13g2_xor2_1
XFILLER_35_19 VPWR VGND sg13g2_decap_8
XFILLER_35_162 VPWR VGND sg13g2_decap_8
XFILLER_36_685 VPWR VGND sg13g2_decap_8
XFILLER_35_195 VPWR VGND sg13g2_decap_8
XFILLER_11_508 VPWR VGND sg13g2_fill_2
X_2907__164 VPWR VGND net164 sg13g2_tiehi
X_2908_ net162 VGND VPWR _0065_ falutop.div_inst.val\[2\] clknet_4_6_0_clk sg13g2_dfrbpq_1
X_2839_ _1023_ _1062_ _1064_ _1177_ VPWR VGND sg13g2_nor3_1
XFILLER_3_718 VPWR VGND sg13g2_decap_8
XFILLER_2_239 VPWR VGND sg13g2_fill_1
XFILLER_47_917 VPWR VGND sg13g2_decap_8
XFILLER_46_416 VPWR VGND sg13g2_decap_8
XFILLER_27_630 VPWR VGND sg13g2_fill_2
XFILLER_42_622 VPWR VGND sg13g2_fill_2
XFILLER_14_302 VPWR VGND sg13g2_decap_4
XFILLER_15_814 VPWR VGND sg13g2_decap_8
XFILLER_27_674 VPWR VGND sg13g2_decap_8
XFILLER_41_132 VPWR VGND sg13g2_decap_8
XFILLER_14_324 VPWR VGND sg13g2_fill_1
XFILLER_26_195 VPWR VGND sg13g2_decap_8
XFILLER_42_666 VPWR VGND sg13g2_fill_1
XFILLER_41_143 VPWR VGND sg13g2_decap_8
XFILLER_14_357 VPWR VGND sg13g2_decap_4
XFILLER_25_85 VPWR VGND sg13g2_decap_8
XFILLER_6_545 VPWR VGND sg13g2_decap_8
XFILLER_10_596 VPWR VGND sg13g2_decap_8
XFILLER_41_95 VPWR VGND sg13g2_fill_1
XFILLER_2_784 VPWR VGND sg13g2_decap_8
XFILLER_1_250 VPWR VGND sg13g2_fill_2
XFILLER_49_265 VPWR VGND sg13g2_fill_2
XFILLER_38_939 VPWR VGND sg13g2_decap_8
XFILLER_37_416 VPWR VGND sg13g2_decap_8
XFILLER_2_78 VPWR VGND sg13g2_decap_8
XFILLER_18_663 VPWR VGND sg13g2_decap_8
XFILLER_17_162 VPWR VGND sg13g2_decap_4
XFILLER_18_696 VPWR VGND sg13g2_decap_8
XFILLER_33_611 VPWR VGND sg13g2_fill_2
XFILLER_17_195 VPWR VGND sg13g2_decap_8
XFILLER_21_806 VPWR VGND sg13g2_decap_8
XFILLER_14_880 VPWR VGND sg13g2_decap_8
XFILLER_20_327 VPWR VGND sg13g2_decap_4
XFILLER_13_390 VPWR VGND sg13g2_decap_8
XFILLER_20_349 VPWR VGND sg13g2_decap_8
XFILLER_9_394 VPWR VGND sg13g2_fill_2
X_2624_ _0964_ net344 net367 VPWR VGND sg13g2_nand2_2
X_2555_ _0049_ _0757_ net296 net409 _0746_ VPWR VGND sg13g2_a22oi_1
X_1506_ _1192_ falutop.div_inst.val\[1\] net318 VPWR VGND sg13g2_nand2_1
X_2486_ falutop.i2c_inst.counter\[0\] falutop.i2c_inst.counter\[1\] _0882_ VPWR VGND
+ sg13g2_nor2b_2
X_2894__34 VPWR VGND net34 sg13g2_tiehi
XFILLER_28_416 VPWR VGND sg13g2_fill_1
XFILLER_37_950 VPWR VGND sg13g2_decap_8
XFILLER_12_828 VPWR VGND sg13g2_decap_8
XFILLER_11_327 VPWR VGND sg13g2_fill_2
XFILLER_23_187 VPWR VGND sg13g2_decap_8
XFILLER_20_894 VPWR VGND sg13g2_decap_8
XFILLER_3_515 VPWR VGND sg13g2_decap_8
XFILLER_11_54 VPWR VGND sg13g2_decap_8
Xfanout340 net341 net340 VPWR VGND sg13g2_buf_8
XFILLER_47_714 VPWR VGND sg13g2_decap_8
Xfanout362 net423 net362 VPWR VGND sg13g2_buf_8
Xfanout351 net429 net351 VPWR VGND sg13g2_buf_8
Xfanout373 net374 net373 VPWR VGND sg13g2_buf_8
Xfanout384 falutop.data_in\[7\] net384 VPWR VGND sg13g2_buf_8
Xfanout395 net399 net395 VPWR VGND sg13g2_buf_8
X_2885__45 VPWR VGND net45 sg13g2_tiehi
XFILLER_4_1028 VPWR VGND sg13g2_fill_1
XFILLER_43_920 VPWR VGND sg13g2_decap_8
XFILLER_15_600 VPWR VGND sg13g2_decap_8
XFILLER_28_972 VPWR VGND sg13g2_decap_8
XFILLER_15_633 VPWR VGND sg13g2_fill_1
XFILLER_43_997 VPWR VGND sg13g2_decap_8
XFILLER_42_463 VPWR VGND sg13g2_decap_8
XFILLER_14_154 VPWR VGND sg13g2_fill_1
XFILLER_42_496 VPWR VGND sg13g2_decap_8
XFILLER_7_821 VPWR VGND sg13g2_decap_8
XFILLER_11_883 VPWR VGND sg13g2_decap_8
XFILLER_7_898 VPWR VGND sg13g2_decap_8
X_2340_ net375 _0759_ VPWR VGND sg13g2_inv_4
X_2271_ net409 VPWR _0703_ VGND falutop.i2c_inst.data_in\[6\] _0702_ sg13g2_o21ai_1
XFILLER_2_581 VPWR VGND sg13g2_decap_8
XFILLER_42_1012 VPWR VGND sg13g2_decap_8
XFILLER_28_4 VPWR VGND sg13g2_decap_8
XFILLER_19_961 VPWR VGND sg13g2_decap_8
X_2891__37 VPWR VGND net37 sg13g2_tiehi
XFILLER_18_471 VPWR VGND sg13g2_decap_8
XFILLER_33_441 VPWR VGND sg13g2_fill_2
XFILLER_33_463 VPWR VGND sg13g2_fill_2
XFILLER_34_964 VPWR VGND sg13g2_decap_8
X_1986_ _0433_ _0422_ _0432_ _0462_ VPWR VGND sg13g2_a21o_1
X_2607_ net406 VPWR _0948_ VGND net412 net312 sg13g2_o21ai_1
X_2538_ _0913_ _0902_ falutop.i2c_inst.result\[14\] _0883_ falutop.i2c_inst.result\[12\]
+ VPWR VGND sg13g2_a22oi_1
X_2469_ _0743_ falutop.i2c_inst.state\[0\] _0867_ VPWR VGND sg13g2_nor2_2
XFILLER_29_747 VPWR VGND sg13g2_fill_2
XFILLER_29_769 VPWR VGND sg13g2_decap_4
XFILLER_44_739 VPWR VGND sg13g2_decap_8
XFILLER_16_408 VPWR VGND sg13g2_fill_1
X_2882__48 VPWR VGND net48 sg13g2_tiehi
XFILLER_43_238 VPWR VGND sg13g2_decap_8
XFILLER_25_931 VPWR VGND sg13g2_decap_8
XFILLER_40_912 VPWR VGND sg13g2_decap_8
XFILLER_19_1003 VPWR VGND sg13g2_decap_8
XFILLER_36_290 VPWR VGND sg13g2_decap_8
XFILLER_11_102 VPWR VGND sg13g2_decap_8
XFILLER_24_474 VPWR VGND sg13g2_decap_8
XFILLER_40_989 VPWR VGND sg13g2_decap_8
XFILLER_11_146 VPWR VGND sg13g2_decap_8
XFILLER_11_179 VPWR VGND sg13g2_decap_8
XFILLER_20_691 VPWR VGND sg13g2_decap_8
XFILLER_22_53 VPWR VGND sg13g2_fill_2
XFILLER_4_846 VPWR VGND sg13g2_decap_8
XFILLER_3_334 VPWR VGND sg13g2_decap_8
XFILLER_47_72 VPWR VGND sg13g2_decap_8
XFILLER_35_706 VPWR VGND sg13g2_decap_4
XFILLER_16_953 VPWR VGND sg13g2_decap_8
XFILLER_43_750 VPWR VGND sg13g2_fill_2
XFILLER_43_794 VPWR VGND sg13g2_decap_8
XFILLER_15_474 VPWR VGND sg13g2_decap_8
XFILLER_31_934 VPWR VGND sg13g2_decap_8
XFILLER_8_22 VPWR VGND sg13g2_fill_2
XFILLER_8_11 VPWR VGND sg13g2_decap_8
X_1840_ VGND VPWR _0314_ _0318_ _0086_ _0319_ sg13g2_a21oi_1
XFILLER_11_680 VPWR VGND sg13g2_decap_8
X_1771_ _0249_ _0250_ _0248_ _0252_ VPWR VGND _0251_ sg13g2_nand4_1
XFILLER_7_695 VPWR VGND sg13g2_decap_8
X_2323_ VPWR _0742_ falutop.i2c_inst.counter\[0\] VGND sg13g2_inv_1
X_2254_ net403 VPWR _0691_ VGND falutop.i2c_inst.data_in\[1\] _0690_ sg13g2_o21ai_1
X_2185_ falutop.data_in\[11\] net298 _0643_ VPWR VGND sg13g2_nor2_1
XFILLER_26_739 VPWR VGND sg13g2_decap_8
XFILLER_25_216 VPWR VGND sg13g2_fill_1
XFILLER_25_227 VPWR VGND sg13g2_decap_8
XFILLER_22_956 VPWR VGND sg13g2_decap_8
XFILLER_21_477 VPWR VGND sg13g2_decap_8
X_1969_ _0398_ _0354_ _0397_ _0446_ VPWR VGND sg13g2_a21o_1
XFILLER_49_1007 VPWR VGND sg13g2_decap_8
XFILLER_1_805 VPWR VGND sg13g2_decap_8
XFILLER_0_337 VPWR VGND sg13g2_decap_8
XFILLER_17_86 VPWR VGND sg13g2_decap_8
XFILLER_17_97 VPWR VGND sg13g2_decap_8
XFILLER_13_912 VPWR VGND sg13g2_decap_8
XFILLER_40_753 VPWR VGND sg13g2_decap_8
XFILLER_8_437 VPWR VGND sg13g2_fill_1
XFILLER_9_938 VPWR VGND sg13g2_decap_8
XFILLER_13_989 VPWR VGND sg13g2_decap_8
XFILLER_33_85 VPWR VGND sg13g2_decap_8
XFILLER_8_459 VPWR VGND sg13g2_decap_8
XFILLER_4_643 VPWR VGND sg13g2_decap_8
XFILLER_3_186 VPWR VGND sg13g2_decap_4
Xhold4 _1080_ VPWR VGND net178 sg13g2_dlygate4sd3_1
XFILLER_48_864 VPWR VGND sg13g2_decap_8
XFILLER_47_385 VPWR VGND sg13g2_fill_2
XFILLER_35_525 VPWR VGND sg13g2_decap_8
XFILLER_35_558 VPWR VGND sg13g2_decap_8
XFILLER_35_569 VPWR VGND sg13g2_fill_1
X_2941_ net85 VGND VPWR _0098_ falutop.alu_data_in\[1\] clknet_4_10_0_clk sg13g2_dfrbpq_1
XFILLER_43_591 VPWR VGND sg13g2_decap_8
X_2872_ net58 VGND VPWR _0029_ falutop.data_in\[1\] net395 sg13g2_dfrbpq_2
X_1823_ _0302_ _1043_ _0303_ VPWR VGND sg13g2_nor2b_2
X_1754_ _0235_ _0231_ _0232_ VPWR VGND sg13g2_xnor2_1
XFILLER_7_492 VPWR VGND sg13g2_decap_8
X_1685_ _0167_ _0164_ _0165_ _1301_ _1200_ VPWR VGND sg13g2_a22oi_1
X_2306_ _0684_ _0689_ _0727_ VPWR VGND sg13g2_nor2_1
X_2237_ net383 VPWR _0678_ VGND falutop.data_in\[12\] _0625_ sg13g2_o21ai_1
XFILLER_26_514 VPWR VGND sg13g2_fill_2
X_2168_ falutop.data_in\[1\] net372 net294 _0098_ VPWR VGND sg13g2_mux2_1
XFILLER_26_558 VPWR VGND sg13g2_decap_4
X_2099_ _0994_ VPWR _0573_ VGND net362 net278 sg13g2_o21ai_1
XFILLER_21_230 VPWR VGND sg13g2_decap_4
XFILLER_22_731 VPWR VGND sg13g2_decap_8
XFILLER_34_591 VPWR VGND sg13g2_decap_8
XFILLER_10_904 VPWR VGND sg13g2_decap_8
XFILLER_22_764 VPWR VGND sg13g2_decap_8
XFILLER_1_602 VPWR VGND sg13g2_decap_8
XFILLER_0_112 VPWR VGND sg13g2_decap_8
X_2917__144 VPWR VGND net144 sg13g2_tiehi
XFILLER_1_679 VPWR VGND sg13g2_decap_8
XFILLER_28_63 VPWR VGND sg13g2_decap_8
XFILLER_45_856 VPWR VGND sg13g2_decap_8
XFILLER_44_322 VPWR VGND sg13g2_decap_8
XFILLER_17_547 VPWR VGND sg13g2_decap_8
XFILLER_17_569 VPWR VGND sg13g2_decap_8
XFILLER_32_506 VPWR VGND sg13g2_decap_8
XFILLER_32_517 VPWR VGND sg13g2_fill_1
XFILLER_13_731 VPWR VGND sg13g2_decap_8
X_2963__153 VPWR VGND net153 sg13g2_tiehi
XFILLER_25_591 VPWR VGND sg13g2_decap_8
XFILLER_9_735 VPWR VGND sg13g2_decap_8
XFILLER_13_786 VPWR VGND sg13g2_decap_8
XFILLER_40_583 VPWR VGND sg13g2_decap_8
XFILLER_4_440 VPWR VGND sg13g2_decap_8
XFILLER_5_996 VPWR VGND sg13g2_decap_8
XFILLER_48_661 VPWR VGND sg13g2_decap_8
XFILLER_10_4 VPWR VGND sg13g2_fill_1
X_2022_ _0496_ _0497_ _0090_ VPWR VGND sg13g2_nor2_1
XFILLER_36_845 VPWR VGND sg13g2_decap_8
XFILLER_36_867 VPWR VGND sg13g2_fill_1
X_2924_ net130 VGND VPWR net269 falutop.i2c_inst.result\[2\] clknet_4_9_0_clk sg13g2_dfrbpq_1
X_2855_ net86 VGND VPWR net206 falutop.div_inst.acc\[5\] clknet_4_2_0_clk sg13g2_dfrbpq_2
XFILLER_31_583 VPWR VGND sg13g2_decap_8
X_1806_ _0285_ _0259_ _0286_ VPWR VGND sg13g2_xor2_1
X_2786_ VGND VPWR _0973_ _1071_ _1125_ _1114_ sg13g2_a21oi_1
X_1737_ _0194_ _0217_ _0218_ VPWR VGND sg13g2_nor2_1
X_1668_ _0150_ _1300_ _0148_ VPWR VGND sg13g2_xnor2_1
X_1599_ _1281_ _1280_ _1283_ VPWR VGND sg13g2_xor2_1
XFILLER_46_609 VPWR VGND sg13g2_decap_8
XFILLER_39_661 VPWR VGND sg13g2_decap_4
XFILLER_42_837 VPWR VGND sg13g2_decap_8
XFILLER_14_528 VPWR VGND sg13g2_fill_1
XFILLER_27_889 VPWR VGND sg13g2_decap_8
XFILLER_10_701 VPWR VGND sg13g2_decap_8
XFILLER_6_727 VPWR VGND sg13g2_decap_8
XFILLER_10_778 VPWR VGND sg13g2_decap_8
XFILLER_30_75 VPWR VGND sg13g2_decap_8
XFILLER_2_966 VPWR VGND sg13g2_decap_8
XFILLER_49_414 VPWR VGND sg13g2_decap_8
XFILLER_1_476 VPWR VGND sg13g2_decap_8
Xclkbuf_4_3_0_clk clknet_0_clk clknet_4_3_0_clk VPWR VGND sg13g2_buf_8
XFILLER_29_171 VPWR VGND sg13g2_decap_8
XFILLER_36_119 VPWR VGND sg13g2_decap_4
XFILLER_44_130 VPWR VGND sg13g2_decap_8
XFILLER_18_856 VPWR VGND sg13g2_decap_8
XFILLER_45_686 VPWR VGND sg13g2_decap_4
XFILLER_17_366 VPWR VGND sg13g2_decap_8
XFILLER_32_303 VPWR VGND sg13g2_fill_2
XFILLER_41_870 VPWR VGND sg13g2_decap_8
XFILLER_9_532 VPWR VGND sg13g2_decap_8
X_2640_ _0979_ _0962_ _0961_ _0980_ VPWR VGND sg13g2_a21o_1
X_2571_ net265 net228 _0773_ _0058_ VPWR VGND sg13g2_mux2_1
XFILLER_5_793 VPWR VGND sg13g2_decap_8
X_1522_ _1207_ net366 net354 net376 net343 VPWR VGND sg13g2_a22oi_1
XFILLER_45_1010 VPWR VGND sg13g2_decap_8
XFILLER_27_119 VPWR VGND sg13g2_decap_8
XFILLER_36_620 VPWR VGND sg13g2_fill_2
X_2005_ _0481_ _0480_ _0416_ VPWR VGND sg13g2_nand2b_1
XFILLER_36_653 VPWR VGND sg13g2_decap_8
XFILLER_35_141 VPWR VGND sg13g2_decap_8
XFILLER_23_336 VPWR VGND sg13g2_decap_8
XFILLER_23_369 VPWR VGND sg13g2_fill_1
X_2907_ net164 VGND VPWR _0064_ falutop.div_inst.val\[1\] clknet_4_6_0_clk sg13g2_dfrbpq_2
X_2838_ VPWR VGND _0971_ _1175_ _1126_ _0969_ _1176_ _1051_ sg13g2_a221oi_1
X_2769_ net326 net375 _0976_ _1108_ VPWR VGND sg13g2_nor3_1
XFILLER_26_174 VPWR VGND sg13g2_decap_8
XFILLER_25_64 VPWR VGND sg13g2_decap_8
XFILLER_41_188 VPWR VGND sg13g2_decap_4
XFILLER_41_74 VPWR VGND sg13g2_decap_8
XFILLER_41_63 VPWR VGND sg13g2_fill_1
XFILLER_41_52 VPWR VGND sg13g2_decap_8
XFILLER_6_524 VPWR VGND sg13g2_decap_8
XFILLER_10_575 VPWR VGND sg13g2_decap_8
XFILLER_2_763 VPWR VGND sg13g2_decap_8
XFILLER_49_244 VPWR VGND sg13g2_decap_8
XFILLER_38_918 VPWR VGND sg13g2_decap_8
XFILLER_2_46 VPWR VGND sg13g2_decap_8
XFILLER_49_299 VPWR VGND sg13g2_decap_8
XFILLER_17_130 VPWR VGND sg13g2_decap_4
XFILLER_18_642 VPWR VGND sg13g2_decap_8
XFILLER_46_995 VPWR VGND sg13g2_decap_8
XFILLER_33_623 VPWR VGND sg13g2_decap_4
XFILLER_33_667 VPWR VGND sg13g2_decap_4
XFILLER_33_689 VPWR VGND sg13g2_decap_8
XFILLER_32_177 VPWR VGND sg13g2_decap_8
XFILLER_9_373 VPWR VGND sg13g2_decap_8
X_2623_ net325 _0763_ _0963_ VPWR VGND sg13g2_nor2_2
X_2554_ VPWR _0048_ _0924_ VGND sg13g2_inv_1
XFILLER_49_0 VPWR VGND sg13g2_decap_8
XFILLER_5_590 VPWR VGND sg13g2_decap_8
X_1505_ _1190_ VPWR _1191_ VGND _1143_ _1145_ sg13g2_o21ai_1
X_2485_ VGND VPWR net286 _0880_ _0022_ _0881_ sg13g2_a21oi_1
XFILLER_24_601 VPWR VGND sg13g2_fill_1
XFILLER_36_483 VPWR VGND sg13g2_decap_4
XFILLER_12_807 VPWR VGND sg13g2_decap_8
XFILLER_24_689 VPWR VGND sg13g2_decap_8
XFILLER_11_306 VPWR VGND sg13g2_decap_8
XFILLER_20_873 VPWR VGND sg13g2_decap_8
XFILLER_11_11 VPWR VGND sg13g2_decap_8
XFILLER_11_88 VPWR VGND sg13g2_decap_8
Xfanout330 net331 net330 VPWR VGND sg13g2_buf_8
Xfanout341 net342 net341 VPWR VGND sg13g2_buf_8
XFILLER_4_1007 VPWR VGND sg13g2_decap_8
Xfanout374 net438 net374 VPWR VGND sg13g2_buf_8
Xfanout352 net355 net352 VPWR VGND sg13g2_buf_8
Xfanout363 net364 net363 VPWR VGND sg13g2_buf_8
Xfanout396 net399 net396 VPWR VGND sg13g2_buf_1
Xfanout385 net386 net385 VPWR VGND sg13g2_buf_8
XFILLER_28_951 VPWR VGND sg13g2_decap_8
XFILLER_36_30 VPWR VGND sg13g2_fill_2
XFILLER_36_52 VPWR VGND sg13g2_fill_2
XFILLER_43_976 VPWR VGND sg13g2_decap_8
XFILLER_14_188 VPWR VGND sg13g2_fill_1
XFILLER_30_615 VPWR VGND sg13g2_decap_8
XFILLER_7_800 VPWR VGND sg13g2_decap_8
XFILLER_10_361 VPWR VGND sg13g2_decap_8
XFILLER_11_862 VPWR VGND sg13g2_decap_8
XFILLER_10_394 VPWR VGND sg13g2_decap_8
XFILLER_10_372 VPWR VGND sg13g2_fill_1
XFILLER_7_877 VPWR VGND sg13g2_decap_8
XFILLER_6_365 VPWR VGND sg13g2_fill_2
XFILLER_2_560 VPWR VGND sg13g2_decap_8
X_2270_ _0692_ _0697_ _0702_ VPWR VGND sg13g2_nor2_1
XFILLER_38_748 VPWR VGND sg13g2_decap_8
XFILLER_38_726 VPWR VGND sg13g2_fill_1
XFILLER_38_715 VPWR VGND sg13g2_decap_8
XFILLER_37_214 VPWR VGND sg13g2_fill_1
XFILLER_37_203 VPWR VGND sg13g2_decap_8
XFILLER_19_940 VPWR VGND sg13g2_decap_8
XFILLER_46_792 VPWR VGND sg13g2_decap_8
XFILLER_34_943 VPWR VGND sg13g2_decap_8
XFILLER_21_604 VPWR VGND sg13g2_fill_1
XFILLER_21_615 VPWR VGND sg13g2_decap_4
XFILLER_21_626 VPWR VGND sg13g2_decap_8
XFILLER_33_475 VPWR VGND sg13g2_decap_8
X_1985_ _0461_ _0370_ _0459_ VPWR VGND sg13g2_xnor2_1
X_2939__91 VPWR VGND net91 sg13g2_tiehi
X_2904__168 VPWR VGND net168 sg13g2_tiehi
X_2606_ VGND VPWR _0850_ net312 _0077_ _0947_ sg13g2_a21oi_1
XFILLER_0_519 VPWR VGND sg13g2_decap_8
X_2537_ _0912_ _0910_ _0911_ VPWR VGND sg13g2_nand2_1
X_2468_ _0866_ net403 _0865_ VPWR VGND sg13g2_nand2_1
X_2399_ _0810_ falutop.div_inst.b1\[1\] falutop.div_inst.acc\[1\] VPWR VGND sg13g2_xnor2_1
XFILLER_25_910 VPWR VGND sg13g2_decap_8
XFILLER_24_453 VPWR VGND sg13g2_decap_4
XFILLER_25_987 VPWR VGND sg13g2_decap_8
XFILLER_40_968 VPWR VGND sg13g2_decap_8
XFILLER_12_659 VPWR VGND sg13g2_decap_8
XFILLER_4_825 VPWR VGND sg13g2_decap_8
XFILLER_3_302 VPWR VGND sg13g2_decap_8
XFILLER_22_98 VPWR VGND sg13g2_decap_8
XFILLER_26_1008 VPWR VGND sg13g2_decap_8
XFILLER_47_512 VPWR VGND sg13g2_fill_1
XFILLER_47_501 VPWR VGND sg13g2_fill_2
XFILLER_47_545 VPWR VGND sg13g2_decap_4
XFILLER_19_236 VPWR VGND sg13g2_decap_4
XFILLER_16_932 VPWR VGND sg13g2_decap_8
XFILLER_28_781 VPWR VGND sg13g2_decap_8
XFILLER_34_228 VPWR VGND sg13g2_decap_8
XFILLER_15_453 VPWR VGND sg13g2_decap_8
X_2927__124 VPWR VGND net124 sg13g2_tiehi
XFILLER_43_773 VPWR VGND sg13g2_decap_8
XFILLER_31_913 VPWR VGND sg13g2_decap_8
XFILLER_30_456 VPWR VGND sg13g2_decap_4
XFILLER_30_489 VPWR VGND sg13g2_fill_2
X_1770_ _0251_ _1045_ _0245_ VPWR VGND sg13g2_nand2_1
XFILLER_7_674 VPWR VGND sg13g2_decap_8
X_2322_ _0741_ falutop.i2c_inst.counter\[2\] VPWR VGND sg13g2_inv_2
X_2253_ _0863_ _0689_ _0690_ VPWR VGND sg13g2_nor2_1
XFILLER_38_534 VPWR VGND sg13g2_fill_1
X_2184_ VGND VPWR _0751_ net295 _0107_ _0642_ sg13g2_a21oi_1
XFILLER_34_751 VPWR VGND sg13g2_decap_8
XFILLER_22_935 VPWR VGND sg13g2_decap_8
XFILLER_34_773 VPWR VGND sg13g2_decap_4
XFILLER_34_795 VPWR VGND sg13g2_decap_8
XFILLER_33_283 VPWR VGND sg13g2_fill_2
X_1968_ _0443_ _0444_ _0445_ VPWR VGND sg13g2_nor2_1
X_1899_ _0377_ net361 net341 net364 net338 VPWR VGND sg13g2_a22oi_1
XFILLER_0_316 VPWR VGND sg13g2_decap_8
XFILLER_0_305 VPWR VGND sg13g2_decap_8
XFILLER_17_32 VPWR VGND sg13g2_decap_8
XFILLER_17_707 VPWR VGND sg13g2_fill_1
XFILLER_29_578 VPWR VGND sg13g2_fill_2
XFILLER_44_537 VPWR VGND sg13g2_decap_8
XFILLER_25_795 VPWR VGND sg13g2_fill_1
XFILLER_9_917 VPWR VGND sg13g2_decap_8
XFILLER_13_968 VPWR VGND sg13g2_decap_8
XFILLER_8_427 VPWR VGND sg13g2_fill_1
XFILLER_8_405 VPWR VGND sg13g2_fill_2
XFILLER_12_478 VPWR VGND sg13g2_decap_8
XFILLER_33_64 VPWR VGND sg13g2_fill_2
XFILLER_32_1023 VPWR VGND sg13g2_decap_4
XFILLER_4_622 VPWR VGND sg13g2_decap_8
XFILLER_4_699 VPWR VGND sg13g2_decap_8
XFILLER_0_883 VPWR VGND sg13g2_decap_8
XFILLER_48_843 VPWR VGND sg13g2_decap_8
XFILLER_12_8 VPWR VGND sg13g2_fill_1
Xhold5 _0080_ VPWR VGND net179 sg13g2_dlygate4sd3_1
XFILLER_47_364 VPWR VGND sg13g2_decap_8
XFILLER_43_570 VPWR VGND sg13g2_decap_8
X_2940_ net87 VGND VPWR _0097_ falutop.alu_data_in\[0\] clknet_4_10_0_clk sg13g2_dfrbpq_2
X_2871_ net59 VGND VPWR _0028_ falutop.data_in\[0\] net394 sg13g2_dfrbpq_2
XFILLER_30_231 VPWR VGND sg13g2_fill_2
XFILLER_31_732 VPWR VGND sg13g2_fill_1
X_1822_ _0989_ net281 _0302_ VPWR VGND sg13g2_nor2_1
X_1753_ VPWR _0234_ _0233_ VGND sg13g2_inv_1
XFILLER_7_471 VPWR VGND sg13g2_decap_8
X_1684_ _1200_ _1301_ _0164_ _0165_ _0166_ VPWR VGND sg13g2_and4_1
XFILLER_31_0 VPWR VGND sg13g2_decap_8
X_2305_ VGND VPWR net391 _0725_ _0144_ _0726_ sg13g2_a21oi_1
XFILLER_39_810 VPWR VGND sg13g2_decap_8
X_2236_ _0677_ VPWR _0124_ VGND net299 _0676_ sg13g2_o21ai_1
XFILLER_38_375 VPWR VGND sg13g2_fill_1
X_2167_ VGND VPWR _0759_ net294 _0097_ _0635_ sg13g2_a21oi_1
X_2098_ _0571_ VPWR _0572_ VGND _0528_ _0567_ sg13g2_o21ai_1
XFILLER_41_529 VPWR VGND sg13g2_decap_4
XFILLER_22_743 VPWR VGND sg13g2_decap_8
XFILLER_21_253 VPWR VGND sg13g2_fill_1
XFILLER_6_909 VPWR VGND sg13g2_decap_8
XFILLER_21_275 VPWR VGND sg13g2_fill_2
XFILLER_21_297 VPWR VGND sg13g2_fill_2
XFILLER_0_135 VPWR VGND sg13g2_fill_1
XFILLER_1_658 VPWR VGND sg13g2_decap_8
XFILLER_49_629 VPWR VGND sg13g2_decap_8
XFILLER_49_618 VPWR VGND sg13g2_decap_8
XFILLER_0_179 VPWR VGND sg13g2_decap_8
XFILLER_0_168 VPWR VGND sg13g2_decap_8
XFILLER_29_353 VPWR VGND sg13g2_decap_8
XFILLER_45_835 VPWR VGND sg13g2_decap_8
XFILLER_44_41 VPWR VGND sg13g2_decap_4
XFILLER_13_710 VPWR VGND sg13g2_decap_8
XFILLER_25_570 VPWR VGND sg13g2_decap_8
XFILLER_9_714 VPWR VGND sg13g2_decap_8
XFILLER_13_765 VPWR VGND sg13g2_decap_8
XFILLER_12_297 VPWR VGND sg13g2_decap_8
XFILLER_5_975 VPWR VGND sg13g2_decap_8
XFILLER_5_79 VPWR VGND sg13g2_decap_8
XFILLER_4_496 VPWR VGND sg13g2_decap_8
XFILLER_0_680 VPWR VGND sg13g2_decap_8
X_2021_ net408 VPWR _0497_ VGND net248 net304 sg13g2_o21ai_1
XFILLER_36_813 VPWR VGND sg13g2_decap_8
XFILLER_47_194 VPWR VGND sg13g2_decap_8
XFILLER_23_518 VPWR VGND sg13g2_decap_4
XFILLER_35_389 VPWR VGND sg13g2_fill_1
X_2923_ net132 VGND VPWR net179 falutop.i2c_inst.result\[1\] clknet_4_9_0_clk sg13g2_dfrbpq_1
X_2854_ net88 VGND VPWR net203 falutop.div_inst.acc\[4\] clknet_4_2_0_clk sg13g2_dfrbpq_2
XFILLER_31_573 VPWR VGND sg13g2_decap_4
X_2785_ _1056_ _1123_ _1022_ _1124_ VPWR VGND sg13g2_nand3_1
X_1805_ _0285_ _0270_ _0284_ VPWR VGND sg13g2_xnor2_1
X_1736_ _0217_ _0203_ _0216_ VPWR VGND sg13g2_xnor2_1
X_1667_ _1300_ _0148_ _0149_ VPWR VGND sg13g2_nor2b_1
X_1598_ _1282_ _1280_ _1281_ VPWR VGND sg13g2_nand2_1
XFILLER_39_640 VPWR VGND sg13g2_decap_8
XFILLER_39_673 VPWR VGND sg13g2_decap_8
X_2219_ _0664_ VPWR _0119_ VGND net300 _0665_ sg13g2_o21ai_1
XFILLER_26_301 VPWR VGND sg13g2_decap_8
XFILLER_27_868 VPWR VGND sg13g2_decap_8
XFILLER_42_816 VPWR VGND sg13g2_decap_8
XFILLER_41_304 VPWR VGND sg13g2_decap_8
XFILLER_41_326 VPWR VGND sg13g2_decap_8
XFILLER_14_11 VPWR VGND sg13g2_decap_8
XFILLER_14_33 VPWR VGND sg13g2_fill_2
XFILLER_14_44 VPWR VGND sg13g2_decap_4
XFILLER_22_584 VPWR VGND sg13g2_decap_8
XFILLER_6_706 VPWR VGND sg13g2_decap_8
XFILLER_10_757 VPWR VGND sg13g2_decap_8
XFILLER_2_945 VPWR VGND sg13g2_decap_8
XFILLER_1_455 VPWR VGND sg13g2_decap_8
XFILLER_18_835 VPWR VGND sg13g2_decap_8
XFILLER_29_150 VPWR VGND sg13g2_decap_8
XFILLER_33_816 VPWR VGND sg13g2_fill_2
XFILLER_33_838 VPWR VGND sg13g2_decap_4
XFILLER_44_186 VPWR VGND sg13g2_decap_8
XFILLER_9_511 VPWR VGND sg13g2_decap_8
XFILLER_13_584 VPWR VGND sg13g2_decap_8
XFILLER_9_588 VPWR VGND sg13g2_decap_8
X_2570_ VPWR _0057_ _0931_ VGND sg13g2_inv_1
XFILLER_5_772 VPWR VGND sg13g2_decap_8
X_1521_ _1206_ _0963_ _0999_ VPWR VGND sg13g2_nand2_1
XFILLER_49_993 VPWR VGND sg13g2_decap_8
X_2004_ _0479_ _0458_ _0480_ VPWR VGND sg13g2_xor2_1
XFILLER_36_632 VPWR VGND sg13g2_decap_8
XFILLER_24_838 VPWR VGND sg13g2_fill_2
XFILLER_24_849 VPWR VGND sg13g2_decap_8
X_2906_ net166 VGND VPWR _0063_ falutop.div_inst.val\[0\] clknet_4_8_0_clk sg13g2_dfrbpq_2
XFILLER_31_381 VPWR VGND sg13g2_decap_8
XFILLER_31_392 VPWR VGND sg13g2_fill_1
X_2837_ _0970_ _1053_ _1175_ VPWR VGND sg13g2_nor2_1
X_2768_ _1105_ _1106_ _1107_ VPWR VGND sg13g2_nor2_1
X_2699_ VGND VPWR _0753_ _0759_ _1039_ _1036_ sg13g2_a21oi_1
X_1719_ _0198_ _0199_ _0200_ VPWR VGND sg13g2_nor2_1
XFILLER_26_153 VPWR VGND sg13g2_decap_8
XFILLER_15_849 VPWR VGND sg13g2_decap_8
XFILLER_25_32 VPWR VGND sg13g2_decap_8
XFILLER_41_167 VPWR VGND sg13g2_decap_8
XFILLER_10_521 VPWR VGND sg13g2_decap_8
XFILLER_22_381 VPWR VGND sg13g2_decap_8
XFILLER_6_503 VPWR VGND sg13g2_decap_8
XFILLER_10_554 VPWR VGND sg13g2_decap_8
XFILLER_2_742 VPWR VGND sg13g2_decap_8
XFILLER_29_1028 VPWR VGND sg13g2_fill_1
XFILLER_1_252 VPWR VGND sg13g2_fill_1
XFILLER_49_212 VPWR VGND sg13g2_decap_8
XFILLER_1_263 VPWR VGND sg13g2_decap_4
XFILLER_2_25 VPWR VGND sg13g2_decap_8
XFILLER_1_296 VPWR VGND sg13g2_decap_8
XFILLER_49_278 VPWR VGND sg13g2_decap_8
XFILLER_46_974 VPWR VGND sg13g2_decap_8
XFILLER_45_473 VPWR VGND sg13g2_decap_8
XFILLER_33_646 VPWR VGND sg13g2_decap_8
XFILLER_32_156 VPWR VGND sg13g2_decap_8
XFILLER_9_352 VPWR VGND sg13g2_decap_8
XFILLER_12_1010 VPWR VGND sg13g2_decap_8
X_2622_ _0962_ _0750_ net368 VPWR VGND sg13g2_nand2_1
X_2553_ _0924_ net252 net296 net410 falutop.i2c_inst.op\[1\] VPWR VGND sg13g2_a22oi_1
X_2937__104 VPWR VGND net104 sg13g2_tiehi
X_1504_ VPWR VGND net308 _1189_ _1162_ _0994_ _1190_ _1146_ sg13g2_a221oi_1
X_2484_ net403 VPWR _0881_ VGND falutop.i2c_inst.counter\[0\] net286 sg13g2_o21ai_1
XFILLER_28_407 VPWR VGND sg13g2_decap_8
XFILLER_49_790 VPWR VGND sg13g2_decap_8
XFILLER_37_985 VPWR VGND sg13g2_decap_8
XFILLER_36_451 VPWR VGND sg13g2_decap_8
XFILLER_23_101 VPWR VGND sg13g2_fill_2
XFILLER_24_624 VPWR VGND sg13g2_decap_8
XFILLER_23_156 VPWR VGND sg13g2_decap_4
XFILLER_24_668 VPWR VGND sg13g2_decap_4
Xclkbuf_4_2_0_clk clknet_0_clk clknet_4_2_0_clk VPWR VGND sg13g2_buf_8
XFILLER_11_45 VPWR VGND sg13g2_decap_4
Xfanout320 net322 net320 VPWR VGND sg13g2_buf_8
Xfanout331 falutop.alu_data_in\[15\] net331 VPWR VGND sg13g2_buf_8
Xfanout375 net430 net375 VPWR VGND sg13g2_buf_8
Xfanout353 net354 net353 VPWR VGND sg13g2_buf_8
Xfanout342 net437 net342 VPWR VGND sg13g2_buf_8
Xfanout364 net365 net364 VPWR VGND sg13g2_buf_8
XFILLER_46_215 VPWR VGND sg13g2_decap_8
XFILLER_46_204 VPWR VGND sg13g2_decap_8
Xfanout397 net399 net397 VPWR VGND sg13g2_buf_8
Xfanout386 net387 net386 VPWR VGND sg13g2_buf_8
XFILLER_19_429 VPWR VGND sg13g2_fill_1
XFILLER_47_749 VPWR VGND sg13g2_decap_8
XFILLER_46_248 VPWR VGND sg13g2_decap_4
XFILLER_28_930 VPWR VGND sg13g2_decap_8
XFILLER_15_613 VPWR VGND sg13g2_decap_4
XFILLER_15_624 VPWR VGND sg13g2_decap_8
XFILLER_27_484 VPWR VGND sg13g2_decap_8
XFILLER_27_495 VPWR VGND sg13g2_fill_1
XFILLER_36_86 VPWR VGND sg13g2_fill_2
XFILLER_43_955 VPWR VGND sg13g2_decap_8
XFILLER_14_123 VPWR VGND sg13g2_decap_8
XFILLER_14_134 VPWR VGND sg13g2_decap_4
XFILLER_15_668 VPWR VGND sg13g2_fill_2
XFILLER_14_178 VPWR VGND sg13g2_fill_1
XFILLER_11_841 VPWR VGND sg13g2_decap_8
XFILLER_10_340 VPWR VGND sg13g2_decap_8
XFILLER_7_856 VPWR VGND sg13g2_decap_8
XFILLER_6_355 VPWR VGND sg13g2_fill_1
XFILLER_35_7 VPWR VGND sg13g2_fill_1
XFILLER_38_705 VPWR VGND sg13g2_fill_2
XFILLER_37_226 VPWR VGND sg13g2_decap_8
XFILLER_46_771 VPWR VGND sg13g2_decap_8
XFILLER_18_451 VPWR VGND sg13g2_fill_1
XFILLER_19_996 VPWR VGND sg13g2_decap_8
XFILLER_34_922 VPWR VGND sg13g2_decap_8
XFILLER_34_999 VPWR VGND sg13g2_decap_8
X_1984_ _0460_ _0459_ net327 VPWR VGND sg13g2_nand2b_1
X_2605_ net406 VPWR _0947_ VGND net414 net312 sg13g2_o21ai_1
X_2536_ _0911_ _0902_ falutop.i2c_inst.result\[10\] _0882_ falutop.i2c_inst.result\[9\]
+ VPWR VGND sg13g2_a22oi_1
X_2467_ _0865_ _0862_ _0864_ falutop.i2c_inst.state\[0\] falutop.i2c_inst.state\[1\]
+ VPWR VGND sg13g2_a22oi_1
X_2398_ _0809_ falutop.div_inst.b1\[0\] falutop.div_inst.acc\[0\] VPWR VGND sg13g2_nand2b_1
XFILLER_29_749 VPWR VGND sg13g2_fill_1
XFILLER_44_719 VPWR VGND sg13g2_decap_8
XFILLER_37_760 VPWR VGND sg13g2_decap_8
XFILLER_28_259 VPWR VGND sg13g2_decap_4
XFILLER_25_966 VPWR VGND sg13g2_decap_8
XFILLER_40_947 VPWR VGND sg13g2_decap_8
XFILLER_12_638 VPWR VGND sg13g2_fill_1
XFILLER_24_498 VPWR VGND sg13g2_decap_8
XFILLER_22_55 VPWR VGND sg13g2_fill_1
XFILLER_4_804 VPWR VGND sg13g2_decap_8
X_2945__73 VPWR VGND net73 sg13g2_tiehi
XFILLER_47_30 VPWR VGND sg13g2_fill_1
XFILLER_19_204 VPWR VGND sg13g2_decap_8
XFILLER_47_524 VPWR VGND sg13g2_decap_8
XFILLER_16_911 VPWR VGND sg13g2_decap_8
XFILLER_16_988 VPWR VGND sg13g2_decap_8
XFILLER_31_969 VPWR VGND sg13g2_decap_8
XFILLER_8_35 VPWR VGND sg13g2_decap_4
XFILLER_7_653 VPWR VGND sg13g2_decap_8
X_2321_ VPWR _0740_ net198 VGND sg13g2_inv_1
X_2252_ _0689_ _0868_ _0883_ VPWR VGND sg13g2_nand2_2
XFILLER_33_4 VPWR VGND sg13g2_fill_1
X_2183_ falutop.data_in\[10\] net295 _0642_ VPWR VGND sg13g2_nor2_1
XFILLER_21_413 VPWR VGND sg13g2_decap_8
XFILLER_22_914 VPWR VGND sg13g2_decap_8
XFILLER_33_295 VPWR VGND sg13g2_fill_1
X_1967_ VGND VPWR _0392_ _0394_ _0444_ _0441_ sg13g2_a21oi_1
X_1898_ _0345_ VPWR _0376_ VGND _0338_ _0346_ sg13g2_o21ai_1
X_2519_ falutop.i2c_inst.data_in\[8\] falutop.data_in\[8\] net319 _0036_ VPWR VGND
+ sg13g2_mux2_1
XFILLER_29_502 VPWR VGND sg13g2_decap_8
XFILLER_17_11 VPWR VGND sg13g2_decap_8
XFILLER_16_229 VPWR VGND sg13g2_decap_8
XFILLER_37_590 VPWR VGND sg13g2_fill_2
XFILLER_25_774 VPWR VGND sg13g2_decap_8
XFILLER_40_722 VPWR VGND sg13g2_decap_8
XFILLER_13_947 VPWR VGND sg13g2_decap_8
XFILLER_24_273 VPWR VGND sg13g2_decap_4
XFILLER_33_43 VPWR VGND sg13g2_decap_8
XFILLER_40_788 VPWR VGND sg13g2_decap_8
XFILLER_32_1002 VPWR VGND sg13g2_decap_8
XFILLER_4_601 VPWR VGND sg13g2_decap_8
XFILLER_4_678 VPWR VGND sg13g2_decap_8
XFILLER_3_166 VPWR VGND sg13g2_fill_2
XFILLER_0_862 VPWR VGND sg13g2_decap_8
XFILLER_48_822 VPWR VGND sg13g2_decap_8
Xhold6 falutop.div_inst.acc_next\[0\] VPWR VGND net180 sg13g2_dlygate4sd3_1
XFILLER_47_332 VPWR VGND sg13g2_decap_8
XFILLER_48_899 VPWR VGND sg13g2_decap_8
XFILLER_47_387 VPWR VGND sg13g2_fill_1
XFILLER_16_741 VPWR VGND sg13g2_fill_1
XFILLER_35_549 VPWR VGND sg13g2_fill_1
XFILLER_16_763 VPWR VGND sg13g2_decap_8
XFILLER_16_774 VPWR VGND sg13g2_fill_2
XFILLER_15_295 VPWR VGND sg13g2_fill_2
X_2870_ net60 VGND VPWR _0027_ falutop.div_inst.start clknet_4_3_0_clk sg13g2_dfrbpq_1
XFILLER_16_796 VPWR VGND sg13g2_decap_4
X_1821_ VGND VPWR _0295_ _0298_ _0301_ _0300_ sg13g2_a21oi_1
XFILLER_8_984 VPWR VGND sg13g2_decap_8
XFILLER_7_450 VPWR VGND sg13g2_decap_8
X_1752_ _0231_ _0232_ _0233_ VPWR VGND sg13g2_nor2_1
X_1683_ _0162_ _0161_ _1344_ _0165_ VPWR VGND sg13g2_a21o_1
X_2304_ net408 VPWR _0726_ VGND falutop.i2c_inst.data_in\[16\] _0725_ sg13g2_o21ai_1
X_2235_ _0677_ net184 net299 VPWR VGND sg13g2_nand2_1
XFILLER_39_855 VPWR VGND sg13g2_fill_1
X_2166_ falutop.data_in\[0\] net294 _0635_ VPWR VGND sg13g2_nor2_1
XFILLER_26_538 VPWR VGND sg13g2_decap_4
X_2097_ net292 _0568_ _0570_ _0571_ VPWR VGND sg13g2_nor3_1
XFILLER_0_91 VPWR VGND sg13g2_decap_8
XFILLER_22_700 VPWR VGND sg13g2_decap_8
XFILLER_34_571 VPWR VGND sg13g2_fill_1
XFILLER_10_939 VPWR VGND sg13g2_decap_8
XFILLER_1_637 VPWR VGND sg13g2_decap_8
XFILLER_0_147 VPWR VGND sg13g2_decap_8
XFILLER_28_32 VPWR VGND sg13g2_decap_8
XFILLER_45_814 VPWR VGND sg13g2_decap_8
XFILLER_44_302 VPWR VGND sg13g2_decap_8
XFILLER_28_98 VPWR VGND sg13g2_decap_8
XFILLER_44_20 VPWR VGND sg13g2_decap_8
XFILLER_44_97 VPWR VGND sg13g2_decap_4
XFILLER_40_563 VPWR VGND sg13g2_fill_2
XFILLER_40_541 VPWR VGND sg13g2_fill_2
XFILLER_8_214 VPWR VGND sg13g2_fill_2
XFILLER_12_276 VPWR VGND sg13g2_decap_8
XFILLER_5_954 VPWR VGND sg13g2_decap_8
XFILLER_5_25 VPWR VGND sg13g2_decap_8
XFILLER_5_58 VPWR VGND sg13g2_decap_8
XFILLER_4_475 VPWR VGND sg13g2_decap_8
X_2900__172 VPWR VGND net172 sg13g2_tiehi
XFILLER_39_118 VPWR VGND sg13g2_decap_8
XFILLER_48_652 VPWR VGND sg13g2_fill_1
XFILLER_47_140 VPWR VGND sg13g2_decap_8
X_2020_ VPWR VGND net317 net307 _0495_ net290 _0496_ _0491_ sg13g2_a221oi_1
XFILLER_48_696 VPWR VGND sg13g2_decap_8
XFILLER_39_1008 VPWR VGND sg13g2_decap_8
X_2922_ net134 VGND VPWR net275 falutop.i2c_inst.result\[0\] clknet_4_9_0_clk sg13g2_dfrbpq_1
X_2853_ net90 VGND VPWR net212 falutop.div_inst.acc\[3\] clknet_4_0_0_clk sg13g2_dfrbpq_2
X_2784_ _0749_ _1020_ net326 _1123_ VPWR VGND sg13g2_nand3_1
X_1804_ _0282_ _0213_ _0284_ VPWR VGND sg13g2_xor2_1
XFILLER_8_781 VPWR VGND sg13g2_decap_8
X_1735_ _0216_ _0156_ _0214_ VPWR VGND sg13g2_xnor2_1
X_1666_ _0147_ _1304_ _0148_ VPWR VGND sg13g2_xor2_1
X_1597_ _1252_ VPWR _1281_ VGND _1236_ _1253_ sg13g2_o21ai_1
XFILLER_22_1012 VPWR VGND sg13g2_decap_8
XFILLER_39_696 VPWR VGND sg13g2_decap_8
XFILLER_38_173 VPWR VGND sg13g2_decap_8
X_2218_ _0663_ falutop.data_in\[6\] _0665_ VPWR VGND sg13g2_xor2_1
XFILLER_27_836 VPWR VGND sg13g2_decap_8
X_2149_ _0621_ falutop.div_inst.rem\[7\] _0620_ VPWR VGND sg13g2_xnor2_1
XFILLER_14_508 VPWR VGND sg13g2_decap_4
XFILLER_22_541 VPWR VGND sg13g2_fill_2
XFILLER_10_736 VPWR VGND sg13g2_decap_8
XFILLER_14_67 VPWR VGND sg13g2_decap_8
XFILLER_22_563 VPWR VGND sg13g2_decap_8
XFILLER_5_206 VPWR VGND sg13g2_decap_8
XFILLER_2_924 VPWR VGND sg13g2_decap_8
XFILLER_1_434 VPWR VGND sg13g2_decap_8
XFILLER_39_42 VPWR VGND sg13g2_fill_2
XFILLER_7_1017 VPWR VGND sg13g2_decap_8
XFILLER_7_1028 VPWR VGND sg13g2_fill_1
XFILLER_45_611 VPWR VGND sg13g2_fill_1
XFILLER_18_814 VPWR VGND sg13g2_decap_8
XFILLER_17_324 VPWR VGND sg13g2_fill_1
XFILLER_45_666 VPWR VGND sg13g2_decap_8
XFILLER_44_198 VPWR VGND sg13g2_decap_8
XFILLER_13_563 VPWR VGND sg13g2_decap_8
XFILLER_9_567 VPWR VGND sg13g2_decap_8
XFILLER_5_751 VPWR VGND sg13g2_decap_8
X_1520_ _1205_ _1164_ _1202_ VPWR VGND sg13g2_xnor2_1
XFILLER_49_972 VPWR VGND sg13g2_decap_8
X_2003_ _0479_ _0461_ _0478_ VPWR VGND sg13g2_xnor2_1
XFILLER_24_806 VPWR VGND sg13g2_decap_8
XFILLER_17_891 VPWR VGND sg13g2_decap_8
XFILLER_35_176 VPWR VGND sg13g2_decap_8
XFILLER_36_699 VPWR VGND sg13g2_decap_4
X_2905_ net167 VGND VPWR _0062_ falutop.div_inst.busy clknet_4_11_0_clk sg13g2_dfrbpq_1
XFILLER_31_360 VPWR VGND sg13g2_decap_8
XFILLER_32_883 VPWR VGND sg13g2_decap_8
X_2836_ _1173_ _0971_ _1174_ VPWR VGND sg13g2_xor2_1
X_2767_ net308 VPWR _1106_ VGND _1036_ _1104_ sg13g2_o21ai_1
XFILLER_2_209 VPWR VGND sg13g2_decap_8
X_1718_ _0199_ net370 net340 net373 net337 VPWR VGND sg13g2_a22oi_1
X_2698_ net380 net379 _1037_ _1038_ VPWR VGND sg13g2_nor3_2
X_1649_ _1332_ net347 net329 VPWR VGND sg13g2_nand2_1
XFILLER_27_644 VPWR VGND sg13g2_decap_4
XFILLER_15_828 VPWR VGND sg13g2_decap_8
XFILLER_25_11 VPWR VGND sg13g2_decap_8
XFILLER_26_132 VPWR VGND sg13g2_decap_8
XFILLER_27_688 VPWR VGND sg13g2_fill_2
XFILLER_42_636 VPWR VGND sg13g2_decap_8
XFILLER_41_113 VPWR VGND sg13g2_fill_2
XFILLER_42_658 VPWR VGND sg13g2_fill_2
XFILLER_41_157 VPWR VGND sg13g2_fill_1
XFILLER_22_360 VPWR VGND sg13g2_fill_1
XFILLER_23_883 VPWR VGND sg13g2_decap_8
XFILLER_10_533 VPWR VGND sg13g2_decap_8
XFILLER_6_559 VPWR VGND sg13g2_decap_8
XFILLER_2_721 VPWR VGND sg13g2_decap_8
XFILLER_29_1007 VPWR VGND sg13g2_decap_8
XFILLER_1_231 VPWR VGND sg13g2_decap_8
XFILLER_2_798 VPWR VGND sg13g2_decap_8
XFILLER_46_953 VPWR VGND sg13g2_decap_8
XFILLER_18_622 VPWR VGND sg13g2_fill_2
XFILLER_45_441 VPWR VGND sg13g2_fill_1
XFILLER_18_677 VPWR VGND sg13g2_decap_8
XFILLER_45_496 VPWR VGND sg13g2_decap_8
XFILLER_32_102 VPWR VGND sg13g2_decap_4
XFILLER_32_135 VPWR VGND sg13g2_decap_8
XFILLER_14_894 VPWR VGND sg13g2_decap_8
XFILLER_9_331 VPWR VGND sg13g2_decap_8
X_2621_ _0958_ _0960_ _0961_ VPWR VGND sg13g2_nor2_2
X_2552_ _0047_ _0756_ net296 net409 _0744_ VPWR VGND sg13g2_a22oi_1
X_1503_ _1172_ _1183_ _1170_ _1189_ VPWR VGND _1188_ sg13g2_nand4_1
X_2483_ VGND VPWR _0742_ _0870_ _0880_ _0871_ sg13g2_a21oi_1
XFILLER_29_909 VPWR VGND sg13g2_decap_8
XFILLER_48_290 VPWR VGND sg13g2_fill_1
XFILLER_37_964 VPWR VGND sg13g2_decap_8
XFILLER_23_113 VPWR VGND sg13g2_decap_8
XFILLER_23_135 VPWR VGND sg13g2_decap_8
XFILLER_32_691 VPWR VGND sg13g2_decap_8
X_2819_ _1154_ _1155_ _1148_ _1157_ VPWR VGND sg13g2_nand3_1
XFILLER_3_529 VPWR VGND sg13g2_decap_8
Xfanout321 net322 net321 VPWR VGND sg13g2_buf_8
Xfanout310 net311 net310 VPWR VGND sg13g2_buf_8
Xfanout332 net333 net332 VPWR VGND sg13g2_buf_8
Xfanout354 net355 net354 VPWR VGND sg13g2_buf_8
Xfanout343 net345 net343 VPWR VGND sg13g2_buf_8
Xfanout365 net422 net365 VPWR VGND sg13g2_buf_8
XFILLER_47_728 VPWR VGND sg13g2_decap_8
Xfanout398 net399 net398 VPWR VGND sg13g2_buf_8
Xfanout387 net388 net387 VPWR VGND sg13g2_buf_8
Xfanout376 falutop.alu_data_in\[0\] net376 VPWR VGND sg13g2_buf_8
XFILLER_27_441 VPWR VGND sg13g2_decap_8
XFILLER_27_452 VPWR VGND sg13g2_fill_2
XFILLER_27_463 VPWR VGND sg13g2_decap_8
XFILLER_28_986 VPWR VGND sg13g2_decap_8
XFILLER_36_32 VPWR VGND sg13g2_fill_1
XFILLER_36_54 VPWR VGND sg13g2_fill_1
XFILLER_43_934 VPWR VGND sg13g2_decap_8
XFILLER_36_65 VPWR VGND sg13g2_decap_8
XFILLER_36_76 VPWR VGND sg13g2_fill_2
XFILLER_36_98 VPWR VGND sg13g2_decap_8
XFILLER_42_477 VPWR VGND sg13g2_fill_1
XFILLER_35_1011 VPWR VGND sg13g2_decap_8
XFILLER_11_820 VPWR VGND sg13g2_decap_8
XFILLER_30_639 VPWR VGND sg13g2_decap_8
XFILLER_7_835 VPWR VGND sg13g2_decap_8
XFILLER_6_334 VPWR VGND sg13g2_decap_8
XFILLER_11_897 VPWR VGND sg13g2_decap_8
XFILLER_42_1026 VPWR VGND sg13g2_fill_2
XFILLER_2_595 VPWR VGND sg13g2_decap_8
XFILLER_46_750 VPWR VGND sg13g2_decap_8
XFILLER_18_430 VPWR VGND sg13g2_fill_2
XFILLER_19_975 VPWR VGND sg13g2_decap_8
XFILLER_34_901 VPWR VGND sg13g2_decap_8
XFILLER_18_485 VPWR VGND sg13g2_decap_8
XFILLER_34_978 VPWR VGND sg13g2_decap_8
X_1983_ _0421_ VPWR _0459_ VGND _0953_ _0419_ sg13g2_o21ai_1
X_2604_ VGND VPWR _0846_ net312 _0076_ _0946_ sg13g2_a21oi_1
X_2535_ _0910_ _0883_ falutop.i2c_inst.result\[8\] falutop.i2c_inst.counter\[2\] falutop.i2c_inst.result\[11\]
+ VPWR VGND sg13g2_a22oi_1
X_2466_ falutop.i2c_inst.counter\[1\] _0743_ _0864_ VPWR VGND sg13g2_nor2_1
X_2397_ falutop.div_inst.b1\[1\] falutop.div_inst.acc\[1\] _0808_ VPWR VGND sg13g2_nor2b_1
XFILLER_3_80 VPWR VGND sg13g2_decap_8
XFILLER_28_205 VPWR VGND sg13g2_decap_8
XFILLER_29_706 VPWR VGND sg13g2_decap_8
XFILLER_43_208 VPWR VGND sg13g2_decap_8
XFILLER_37_783 VPWR VGND sg13g2_decap_8
XFILLER_19_1017 VPWR VGND sg13g2_decap_8
XFILLER_25_945 VPWR VGND sg13g2_decap_8
XFILLER_40_926 VPWR VGND sg13g2_decap_8
XFILLER_19_1028 VPWR VGND sg13g2_fill_1
XFILLER_24_466 VPWR VGND sg13g2_fill_2
XFILLER_24_488 VPWR VGND sg13g2_fill_2
XFILLER_11_116 VPWR VGND sg13g2_decap_8
XFILLER_3_348 VPWR VGND sg13g2_decap_8
XFILLER_47_86 VPWR VGND sg13g2_decap_8
XFILLER_27_260 VPWR VGND sg13g2_decap_8
XFILLER_42_230 VPWR VGND sg13g2_decap_8
XFILLER_16_967 VPWR VGND sg13g2_decap_8
XFILLER_42_296 VPWR VGND sg13g2_decap_8
XFILLER_15_488 VPWR VGND sg13g2_decap_8
XFILLER_31_948 VPWR VGND sg13g2_decap_8
XFILLER_8_69 VPWR VGND sg13g2_decap_8
XFILLER_7_632 VPWR VGND sg13g2_decap_8
XFILLER_11_694 VPWR VGND sg13g2_decap_8
X_2320_ VPWR _0739_ net222 VGND sg13g2_inv_1
X_2251_ VGND VPWR net390 _0878_ _0128_ _0688_ sg13g2_a21oi_1
XFILLER_3_893 VPWR VGND sg13g2_decap_8
XFILLER_2_392 VPWR VGND sg13g2_decap_8
XFILLER_38_503 VPWR VGND sg13g2_decap_8
XFILLER_26_4 VPWR VGND sg13g2_decap_8
X_2182_ VGND VPWR _0749_ net294 _0106_ _0641_ sg13g2_a21oi_1
XFILLER_38_558 VPWR VGND sg13g2_decap_4
Xclkbuf_4_1_0_clk clknet_0_clk clknet_4_1_0_clk VPWR VGND sg13g2_buf_8
XFILLER_19_783 VPWR VGND sg13g2_decap_8
XFILLER_46_580 VPWR VGND sg13g2_decap_8
XFILLER_21_436 VPWR VGND sg13g2_fill_2
XFILLER_33_285 VPWR VGND sg13g2_fill_1
X_1966_ VPWR _0443_ _0442_ VGND sg13g2_inv_1
XFILLER_21_447 VPWR VGND sg13g2_decap_8
XFILLER_21_458 VPWR VGND sg13g2_fill_1
X_1897_ _0375_ _0328_ _0374_ VPWR VGND sg13g2_xnor2_1
X_2518_ falutop.i2c_inst.data_in\[7\] falutop.data_in\[7\] net320 _0035_ VPWR VGND
+ sg13g2_mux2_1
XFILLER_1_819 VPWR VGND sg13g2_decap_8
X_2449_ VPWR _0853_ _0852_ VGND sg13g2_inv_1
XFILLER_29_547 VPWR VGND sg13g2_decap_4
XFILLER_25_742 VPWR VGND sg13g2_decap_4
XFILLER_12_403 VPWR VGND sg13g2_fill_2
XFILLER_13_926 VPWR VGND sg13g2_decap_8
XFILLER_40_767 VPWR VGND sg13g2_decap_8
XFILLER_8_418 VPWR VGND sg13g2_fill_2
XFILLER_8_407 VPWR VGND sg13g2_fill_1
XFILLER_12_447 VPWR VGND sg13g2_fill_2
XFILLER_33_66 VPWR VGND sg13g2_fill_1
XFILLER_21_981 VPWR VGND sg13g2_decap_8
XFILLER_33_99 VPWR VGND sg13g2_decap_8
XFILLER_4_657 VPWR VGND sg13g2_decap_8
XFILLER_0_841 VPWR VGND sg13g2_decap_8
XFILLER_48_801 VPWR VGND sg13g2_decap_8
Xhold7 _0006_ VPWR VGND net181 sg13g2_dlygate4sd3_1
XFILLER_48_878 VPWR VGND sg13g2_decap_8
XFILLER_47_399 VPWR VGND sg13g2_decap_8
XFILLER_16_720 VPWR VGND sg13g2_decap_8
XFILLER_31_701 VPWR VGND sg13g2_decap_4
XFILLER_15_263 VPWR VGND sg13g2_fill_2
XFILLER_30_222 VPWR VGND sg13g2_fill_2
XFILLER_31_745 VPWR VGND sg13g2_decap_8
XFILLER_30_233 VPWR VGND sg13g2_fill_1
X_1820_ _0300_ net308 _0299_ VPWR VGND sg13g2_nand2b_1
XFILLER_31_778 VPWR VGND sg13g2_decap_8
XFILLER_31_789 VPWR VGND sg13g2_fill_2
XFILLER_8_963 VPWR VGND sg13g2_decap_8
XFILLER_7_440 VPWR VGND sg13g2_fill_1
X_1751_ VGND VPWR _1327_ _1334_ _0232_ _1336_ sg13g2_a21oi_1
XFILLER_30_299 VPWR VGND sg13g2_fill_2
X_1682_ _0161_ _0162_ _1344_ _0164_ VPWR VGND sg13g2_nand3_1
X_2303_ _0877_ _0684_ _0725_ VPWR VGND sg13g2_nor2_1
XFILLER_3_690 VPWR VGND sg13g2_decap_8
XFILLER_39_845 VPWR VGND sg13g2_fill_2
X_2234_ _0675_ falutop.data_in\[12\] _0676_ VPWR VGND sg13g2_xor2_1
X_2165_ VPWR _0096_ _0634_ VGND sg13g2_inv_1
XFILLER_39_889 VPWR VGND sg13g2_decap_8
X_2096_ _0526_ _0566_ _0570_ VPWR VGND sg13g2_nor2_1
XFILLER_0_70 VPWR VGND sg13g2_decap_8
XFILLER_0_1023 VPWR VGND sg13g2_decap_4
XFILLER_21_200 VPWR VGND sg13g2_decap_8
XFILLER_10_918 VPWR VGND sg13g2_decap_8
XFILLER_16_1009 VPWR VGND sg13g2_decap_8
XFILLER_22_778 VPWR VGND sg13g2_decap_8
XFILLER_21_277 VPWR VGND sg13g2_fill_1
X_1949_ _0426_ net328 net368 VPWR VGND sg13g2_nand2_2
XFILLER_21_299 VPWR VGND sg13g2_fill_1
XFILLER_1_616 VPWR VGND sg13g2_decap_8
XFILLER_0_126 VPWR VGND sg13g2_decap_8
XFILLER_28_11 VPWR VGND sg13g2_decap_8
XFILLER_17_506 VPWR VGND sg13g2_decap_8
XFILLER_28_77 VPWR VGND sg13g2_decap_8
XFILLER_29_377 VPWR VGND sg13g2_fill_2
XFILLER_44_336 VPWR VGND sg13g2_fill_1
XFILLER_44_76 VPWR VGND sg13g2_decap_8
XFILLER_40_520 VPWR VGND sg13g2_decap_8
XFILLER_40_597 VPWR VGND sg13g2_decap_8
XFILLER_9_749 VPWR VGND sg13g2_decap_8
XFILLER_12_255 VPWR VGND sg13g2_decap_8
XFILLER_5_933 VPWR VGND sg13g2_decap_8
XFILLER_4_454 VPWR VGND sg13g2_decap_8
XFILLER_16_572 VPWR VGND sg13g2_fill_1
X_2921_ net136 VGND VPWR _0078_ falutop.div_inst.rem\[7\] clknet_4_9_0_clk sg13g2_dfrbpq_1
XFILLER_31_531 VPWR VGND sg13g2_decap_4
X_2852_ net92 VGND VPWR net214 falutop.div_inst.acc\[2\] clknet_4_0_0_clk sg13g2_dfrbpq_2
X_2783_ _1117_ _1115_ _1121_ _1122_ VPWR VGND sg13g2_a21o_1
X_1803_ _0213_ _0282_ _0283_ VPWR VGND sg13g2_nor2_1
XFILLER_31_597 VPWR VGND sg13g2_decap_8
XFILLER_8_760 VPWR VGND sg13g2_decap_8
X_1734_ _0157_ _0214_ _0215_ VPWR VGND sg13g2_nor2_1
X_1665_ _1345_ _1347_ _0147_ VPWR VGND sg13g2_nor2_1
X_1596_ _1280_ _1266_ _1279_ VPWR VGND sg13g2_xnor2_1
X_2217_ _0664_ net185 net300 VPWR VGND sg13g2_nand2_1
XFILLER_27_815 VPWR VGND sg13g2_decap_8
X_2148_ net382 VPWR _0620_ VGND falutop.div_inst.rem\[6\] _0577_ sg13g2_o21ai_1
X_2079_ _0553_ _0550_ _0552_ VPWR VGND sg13g2_xnor2_1
XFILLER_26_358 VPWR VGND sg13g2_decap_4
XFILLER_22_520 VPWR VGND sg13g2_decap_8
XFILLER_35_870 VPWR VGND sg13g2_fill_2
XFILLER_35_892 VPWR VGND sg13g2_decap_8
XFILLER_10_715 VPWR VGND sg13g2_decap_8
XFILLER_30_12 VPWR VGND sg13g2_fill_1
XFILLER_2_903 VPWR VGND sg13g2_decap_8
XFILLER_30_89 VPWR VGND sg13g2_decap_4
XFILLER_1_413 VPWR VGND sg13g2_decap_8
XFILLER_49_439 VPWR VGND sg13g2_decap_8
XFILLER_17_303 VPWR VGND sg13g2_decap_8
XFILLER_45_634 VPWR VGND sg13g2_decap_8
XFILLER_29_185 VPWR VGND sg13g2_decap_8
XFILLER_44_144 VPWR VGND sg13g2_decap_8
XFILLER_33_818 VPWR VGND sg13g2_fill_1
XFILLER_13_531 VPWR VGND sg13g2_decap_8
XFILLER_41_884 VPWR VGND sg13g2_decap_8
XFILLER_40_372 VPWR VGND sg13g2_decap_8
XFILLER_9_546 VPWR VGND sg13g2_decap_8
XFILLER_5_730 VPWR VGND sg13g2_decap_8
XFILLER_4_251 VPWR VGND sg13g2_fill_2
XFILLER_4_240 VPWR VGND sg13g2_decap_8
XFILLER_45_1024 VPWR VGND sg13g2_decap_4
XFILLER_1_980 VPWR VGND sg13g2_decap_8
XFILLER_49_951 VPWR VGND sg13g2_decap_8
X_2002_ _0478_ _0462_ _0476_ VPWR VGND sg13g2_xnor2_1
XFILLER_35_100 VPWR VGND sg13g2_decap_8
XFILLER_35_155 VPWR VGND sg13g2_decap_8
XFILLER_36_667 VPWR VGND sg13g2_fill_2
XFILLER_17_870 VPWR VGND sg13g2_decap_8
X_2904_ net168 VGND VPWR _0061_ falutop.div_inst.b1\[7\] clknet_4_8_0_clk sg13g2_dfrbpq_2
X_2835_ _0974_ VPWR _1173_ VGND _0975_ _1000_ sg13g2_o21ai_1
X_2766_ _1036_ _1104_ _1105_ VPWR VGND sg13g2_and2_1
X_1717_ VPWR _0198_ _0197_ VGND sg13g2_inv_1
X_2697_ _1037_ falutop.alu_inst.op\[0\] net377 VPWR VGND sg13g2_nand2_1
XFILLER_6_91 VPWR VGND sg13g2_fill_2
X_1648_ _1330_ VPWR _1331_ VGND net360 _1268_ sg13g2_o21ai_1
X_1579_ VGND VPWR net305 _1262_ _0082_ _1263_ sg13g2_a21oi_1
XFILLER_46_409 VPWR VGND sg13g2_decap_8
XFILLER_39_472 VPWR VGND sg13g2_decap_8
XFILLER_15_807 VPWR VGND sg13g2_decap_8
XFILLER_27_667 VPWR VGND sg13g2_decap_8
XFILLER_42_615 VPWR VGND sg13g2_decap_8
XFILLER_14_306 VPWR VGND sg13g2_fill_2
XFILLER_14_317 VPWR VGND sg13g2_decap_8
XFILLER_26_188 VPWR VGND sg13g2_decap_8
XFILLER_41_125 VPWR VGND sg13g2_decap_8
XFILLER_25_78 VPWR VGND sg13g2_decap_8
XFILLER_41_11 VPWR VGND sg13g2_decap_8
X_2960__159 VPWR VGND net159 sg13g2_tiehi
XFILLER_41_88 VPWR VGND sg13g2_decap_8
XFILLER_6_538 VPWR VGND sg13g2_decap_8
XFILLER_10_589 VPWR VGND sg13g2_decap_8
XFILLER_2_700 VPWR VGND sg13g2_decap_8
XFILLER_2_777 VPWR VGND sg13g2_decap_8
XFILLER_49_258 VPWR VGND sg13g2_decap_8
XFILLER_37_409 VPWR VGND sg13g2_decap_8
XFILLER_18_601 VPWR VGND sg13g2_decap_8
XFILLER_46_932 VPWR VGND sg13g2_decap_8
XFILLER_18_656 VPWR VGND sg13g2_decap_8
XFILLER_33_604 VPWR VGND sg13g2_decap_8
XFILLER_17_166 VPWR VGND sg13g2_fill_1
XFILLER_18_689 VPWR VGND sg13g2_decap_8
XFILLER_14_873 VPWR VGND sg13g2_decap_8
XFILLER_40_191 VPWR VGND sg13g2_fill_2
X_2620_ net342 net365 _0960_ VPWR VGND sg13g2_nor2_2
XFILLER_9_387 VPWR VGND sg13g2_decap_8
X_2551_ _0923_ net409 _0897_ VPWR VGND sg13g2_nand2_2
X_2482_ _0878_ _0865_ _0879_ VPWR VGND sg13g2_nor2b_2
X_1502_ VGND VPWR _1188_ _1187_ _1184_ sg13g2_or2_1
XFILLER_37_943 VPWR VGND sg13g2_decap_8
XFILLER_20_854 VPWR VGND sg13g2_fill_2
X_2818_ _1156_ _1148_ _1154_ _1155_ VPWR VGND sg13g2_and3_1
XFILLER_20_887 VPWR VGND sg13g2_decap_8
XFILLER_3_508 VPWR VGND sg13g2_decap_8
X_2749_ _1088_ _1015_ _1086_ VPWR VGND sg13g2_xnor2_1
Xfanout322 _0855_ net322 VPWR VGND sg13g2_buf_8
Xfanout311 net314 net311 VPWR VGND sg13g2_buf_1
Xfanout300 _0901_ net300 VPWR VGND sg13g2_buf_8
Xfanout355 falutop.alu_data_in\[8\] net355 VPWR VGND sg13g2_buf_8
Xfanout366 falutop.alu_data_in\[3\] net366 VPWR VGND sg13g2_buf_8
Xfanout333 net334 net333 VPWR VGND sg13g2_buf_8
Xfanout344 net345 net344 VPWR VGND sg13g2_buf_8
XFILLER_47_707 VPWR VGND sg13g2_decap_8
Xfanout399 ui_in[2] net399 VPWR VGND sg13g2_buf_8
Xfanout377 falutop.alu_inst.op\[3\] net377 VPWR VGND sg13g2_buf_8
Xfanout388 net435 net388 VPWR VGND sg13g2_buf_8
XFILLER_28_965 VPWR VGND sg13g2_decap_8
XFILLER_43_913 VPWR VGND sg13g2_decap_8
XFILLER_42_434 VPWR VGND sg13g2_fill_1
XFILLER_42_489 VPWR VGND sg13g2_decap_8
XFILLER_42_456 VPWR VGND sg13g2_decap_8
XFILLER_7_814 VPWR VGND sg13g2_decap_8
XFILLER_11_876 VPWR VGND sg13g2_decap_8
XFILLER_2_574 VPWR VGND sg13g2_decap_8
XFILLER_42_1005 VPWR VGND sg13g2_decap_8
XFILLER_19_954 VPWR VGND sg13g2_decap_8
XFILLER_18_464 VPWR VGND sg13g2_decap_8
XFILLER_34_957 VPWR VGND sg13g2_decap_8
XFILLER_33_456 VPWR VGND sg13g2_decap_8
X_1982_ VGND VPWR _0417_ _0436_ _0458_ _0435_ sg13g2_a21oi_1
XFILLER_33_489 VPWR VGND sg13g2_fill_2
X_2603_ net406 VPWR _0946_ VGND net411 net312 sg13g2_o21ai_1
X_2534_ _0905_ _0908_ _0889_ _0909_ VPWR VGND sg13g2_nand3_1
XFILLER_47_0 VPWR VGND sg13g2_decap_8
X_2465_ _0863_ _0741_ _0861_ VPWR VGND sg13g2_nand2_2
X_2396_ _0807_ falutop.div_inst.acc\[2\] falutop.div_inst.b1\[2\] VPWR VGND sg13g2_nand2b_1
XFILLER_24_412 VPWR VGND sg13g2_decap_8
XFILLER_25_924 VPWR VGND sg13g2_decap_8
XFILLER_40_905 VPWR VGND sg13g2_decap_8
XFILLER_20_651 VPWR VGND sg13g2_decap_8
XFILLER_22_46 VPWR VGND sg13g2_decap_8
X_2959__161 VPWR VGND net161 sg13g2_tiehi
XFILLER_4_839 VPWR VGND sg13g2_decap_8
XFILLER_3_327 VPWR VGND sg13g2_decap_8
XFILLER_47_21 VPWR VGND sg13g2_decap_8
XFILLER_47_65 VPWR VGND sg13g2_decap_8
XFILLER_28_740 VPWR VGND sg13g2_decap_8
XFILLER_28_795 VPWR VGND sg13g2_decap_8
XFILLER_34_209 VPWR VGND sg13g2_decap_8
XFILLER_43_743 VPWR VGND sg13g2_decap_8
XFILLER_15_423 VPWR VGND sg13g2_decap_4
XFILLER_16_946 VPWR VGND sg13g2_decap_8
XFILLER_27_272 VPWR VGND sg13g2_decap_8
XFILLER_43_787 VPWR VGND sg13g2_decap_8
XFILLER_15_467 VPWR VGND sg13g2_decap_8
XFILLER_31_927 VPWR VGND sg13g2_decap_8
XFILLER_7_611 VPWR VGND sg13g2_decap_8
XFILLER_11_673 VPWR VGND sg13g2_decap_8
XFILLER_10_194 VPWR VGND sg13g2_decap_8
XFILLER_10_183 VPWR VGND sg13g2_fill_2
XFILLER_6_132 VPWR VGND sg13g2_decap_8
XFILLER_7_688 VPWR VGND sg13g2_decap_8
XFILLER_40_7 VPWR VGND sg13g2_decap_8
XFILLER_3_872 VPWR VGND sg13g2_decap_8
X_2250_ net402 VPWR _0688_ VGND falutop.i2c_inst.data_in\[0\] _0878_ sg13g2_o21ai_1
XFILLER_2_371 VPWR VGND sg13g2_decap_8
X_2181_ falutop.data_in\[9\] net294 _0641_ VPWR VGND sg13g2_nor2_1
XFILLER_19_4 VPWR VGND sg13g2_decap_4
X_2857__82 VPWR VGND net82 sg13g2_tiehi
XFILLER_18_261 VPWR VGND sg13g2_fill_1
XFILLER_25_209 VPWR VGND sg13g2_decap_8
XFILLER_22_949 VPWR VGND sg13g2_decap_8
XFILLER_33_275 VPWR VGND sg13g2_decap_4
X_1965_ _0394_ _0441_ _0392_ _0442_ VPWR VGND sg13g2_nand3_1
XFILLER_30_993 VPWR VGND sg13g2_decap_8
X_1896_ _0371_ _0369_ _0374_ VPWR VGND sg13g2_xor2_1
X_2517_ falutop.i2c_inst.data_in\[6\] falutop.data_in\[6\] net321 _0034_ VPWR VGND
+ sg13g2_mux2_1
X_2448_ _0852_ net283 _0851_ _0823_ _0747_ VPWR VGND sg13g2_a22oi_1
XFILLER_25_1022 VPWR VGND sg13g2_decap_8
X_2379_ VGND VPWR net385 falutop.div_inst.a\[5\] _0793_ _0792_ sg13g2_a21oi_1
XFILLER_17_68 VPWR VGND sg13g2_decap_4
X_2863__74 VPWR VGND net74 sg13g2_tiehi
XFILLER_13_905 VPWR VGND sg13g2_decap_8
XFILLER_21_960 VPWR VGND sg13g2_decap_8
XFILLER_33_78 VPWR VGND sg13g2_decap_8
XFILLER_4_636 VPWR VGND sg13g2_decap_8
XFILLER_3_124 VPWR VGND sg13g2_decap_4
XFILLER_3_113 VPWR VGND sg13g2_fill_1
XFILLER_0_820 VPWR VGND sg13g2_decap_8
XFILLER_0_897 VPWR VGND sg13g2_decap_8
Xhold8 falutop.div_inst.quo\[4\] VPWR VGND net182 sg13g2_dlygate4sd3_1
XFILLER_48_857 VPWR VGND sg13g2_decap_8
XFILLER_47_323 VPWR VGND sg13g2_decap_4
XFILLER_47_378 VPWR VGND sg13g2_fill_2
XFILLER_35_518 VPWR VGND sg13g2_decap_8
XFILLER_43_551 VPWR VGND sg13g2_decap_4
XFILLER_43_584 VPWR VGND sg13g2_decap_8
XFILLER_12_982 VPWR VGND sg13g2_decap_8
X_1750_ _0231_ _0229_ _0230_ VPWR VGND sg13g2_nand2_1
XFILLER_8_942 VPWR VGND sg13g2_decap_8
XFILLER_7_485 VPWR VGND sg13g2_decap_8
X_1681_ _0161_ _0162_ _0163_ VPWR VGND sg13g2_and2_1
XFILLER_48_1011 VPWR VGND sg13g2_decap_8
X_2302_ VGND VPWR net389 _0723_ _0143_ _0724_ sg13g2_a21oi_1
XFILLER_39_824 VPWR VGND sg13g2_decap_8
X_2233_ _0675_ net383 _0625_ VPWR VGND sg13g2_nand2_1
XFILLER_38_334 VPWR VGND sg13g2_decap_8
X_2164_ _0634_ _0633_ net384 net300 net240 VPWR VGND sg13g2_a22oi_1
XFILLER_0_1002 VPWR VGND sg13g2_decap_8
XFILLER_26_507 VPWR VGND sg13g2_decap_8
X_2095_ _0499_ _0500_ _0527_ _0566_ _0569_ VPWR VGND sg13g2_or4_1
XFILLER_19_592 VPWR VGND sg13g2_decap_8
XFILLER_34_562 VPWR VGND sg13g2_decap_8
XFILLER_22_724 VPWR VGND sg13g2_decap_8
XFILLER_34_584 VPWR VGND sg13g2_decap_8
X_2860__77 VPWR VGND net77 sg13g2_tiehi
XFILLER_21_234 VPWR VGND sg13g2_fill_2
XFILLER_22_757 VPWR VGND sg13g2_fill_2
X_1948_ net328 net368 _0425_ VPWR VGND sg13g2_and2_1
X_1879_ _0986_ _0311_ _0358_ VPWR VGND sg13g2_and2_1
XFILLER_0_105 VPWR VGND sg13g2_decap_8
XFILLER_28_56 VPWR VGND sg13g2_decap_8
XFILLER_45_849 VPWR VGND sg13g2_decap_8
XFILLER_38_890 VPWR VGND sg13g2_decap_8
XFILLER_13_724 VPWR VGND sg13g2_decap_8
XFILLER_25_584 VPWR VGND sg13g2_fill_2
XFILLER_12_223 VPWR VGND sg13g2_fill_2
XFILLER_12_245 VPWR VGND sg13g2_decap_4
XFILLER_40_576 VPWR VGND sg13g2_decap_8
XFILLER_40_565 VPWR VGND sg13g2_fill_1
XFILLER_8_227 VPWR VGND sg13g2_decap_4
XFILLER_9_728 VPWR VGND sg13g2_decap_8
XFILLER_13_779 VPWR VGND sg13g2_decap_8
XFILLER_21_790 VPWR VGND sg13g2_decap_8
XFILLER_5_912 VPWR VGND sg13g2_decap_8
Xclkbuf_4_0_0_clk clknet_0_clk clknet_4_0_0_clk VPWR VGND sg13g2_buf_8
XFILLER_4_433 VPWR VGND sg13g2_decap_8
XFILLER_5_989 VPWR VGND sg13g2_decap_8
X_2970__139 VPWR VGND net139 sg13g2_tiehi
XFILLER_0_694 VPWR VGND sg13g2_decap_8
XFILLER_36_827 VPWR VGND sg13g2_decap_4
XFILLER_36_838 VPWR VGND sg13g2_decap_8
XFILLER_16_551 VPWR VGND sg13g2_fill_2
XFILLER_44_893 VPWR VGND sg13g2_decap_8
XFILLER_43_370 VPWR VGND sg13g2_fill_1
X_2920_ net138 VGND VPWR _0077_ falutop.div_inst.rem\[6\] clknet_4_8_0_clk sg13g2_dfrbpq_2
X_2851_ net94 VGND VPWR net210 falutop.div_inst.acc\[1\] clknet_4_0_0_clk sg13g2_dfrbpq_2
XFILLER_15_1010 VPWR VGND sg13g2_decap_8
X_2782_ _1120_ VPWR _1121_ VGND _1108_ _1109_ sg13g2_o21ai_1
X_1802_ _0282_ _0276_ _0281_ VPWR VGND sg13g2_xnor2_1
X_1733_ _0214_ _0208_ _0212_ VPWR VGND sg13g2_xnor2_1
X_1664_ _1347_ net370 net344 net373 net340 VPWR VGND sg13g2_a22oi_1
X_1595_ _1276_ _1267_ _1279_ VPWR VGND sg13g2_xor2_1
XFILLER_39_654 VPWR VGND sg13g2_decap_8
X_2216_ _0663_ net384 _0632_ VPWR VGND sg13g2_nand2_1
XFILLER_38_142 VPWR VGND sg13g2_decap_8
X_2147_ net291 VPWR _0619_ VGND _0617_ _0618_ sg13g2_o21ai_1
X_2078_ _0552_ _0426_ _0551_ VPWR VGND sg13g2_xnor2_1
XFILLER_34_392 VPWR VGND sg13g2_decap_8
XFILLER_22_598 VPWR VGND sg13g2_decap_4
XFILLER_30_68 VPWR VGND sg13g2_decap_8
XFILLER_2_959 VPWR VGND sg13g2_decap_8
XFILLER_49_407 VPWR VGND sg13g2_decap_8
XFILLER_39_44 VPWR VGND sg13g2_fill_1
XFILLER_1_469 VPWR VGND sg13g2_decap_8
XFILLER_18_805 VPWR VGND sg13g2_fill_1
XFILLER_44_101 VPWR VGND sg13g2_fill_2
XFILLER_18_849 VPWR VGND sg13g2_decap_8
XFILLER_29_164 VPWR VGND sg13g2_decap_8
XFILLER_13_510 VPWR VGND sg13g2_fill_1
XFILLER_26_882 VPWR VGND sg13g2_decap_8
XFILLER_41_863 VPWR VGND sg13g2_decap_8
XFILLER_9_525 VPWR VGND sg13g2_decap_8
XFILLER_13_598 VPWR VGND sg13g2_decap_8
XFILLER_5_786 VPWR VGND sg13g2_decap_8
XFILLER_45_1003 VPWR VGND sg13g2_decap_8
XFILLER_49_930 VPWR VGND sg13g2_decap_8
XFILLER_0_491 VPWR VGND sg13g2_decap_8
XFILLER_48_451 VPWR VGND sg13g2_decap_4
X_2001_ _0476_ _0462_ _0477_ VPWR VGND sg13g2_nor2b_1
XFILLER_36_602 VPWR VGND sg13g2_decap_8
XFILLER_48_473 VPWR VGND sg13g2_fill_1
XFILLER_36_646 VPWR VGND sg13g2_decap_8
XFILLER_35_134 VPWR VGND sg13g2_decap_8
XFILLER_32_852 VPWR VGND sg13g2_decap_4
X_2903_ net169 VGND VPWR _0060_ falutop.div_inst.b1\[6\] clknet_4_2_0_clk sg13g2_dfrbpq_1
X_2834_ _1043_ _1171_ _0978_ _1172_ VPWR VGND sg13g2_nand3_1
X_2765_ _1103_ _1099_ _1104_ VPWR VGND sg13g2_xor2_1
X_2696_ _0753_ _1000_ _1036_ VPWR VGND sg13g2_nor2_1
X_1716_ net340 net373 net337 _0197_ VPWR VGND net370 sg13g2_nand4_1
X_1647_ _1330_ net350 _1329_ VPWR VGND sg13g2_nand2_1
X_1578_ net407 VPWR _1263_ VGND net259 net305 sg13g2_o21ai_1
XFILLER_39_451 VPWR VGND sg13g2_fill_2
XFILLER_26_123 VPWR VGND sg13g2_decap_4
XFILLER_26_167 VPWR VGND sg13g2_decap_8
XFILLER_25_57 VPWR VGND sg13g2_decap_8
XFILLER_22_395 VPWR VGND sg13g2_decap_8
XFILLER_41_45 VPWR VGND sg13g2_decap_8
XFILLER_6_517 VPWR VGND sg13g2_decap_8
XFILLER_10_568 VPWR VGND sg13g2_decap_8
XFILLER_2_756 VPWR VGND sg13g2_decap_8
XFILLER_49_237 VPWR VGND sg13g2_decap_8
XFILLER_2_39 VPWR VGND sg13g2_decap_8
XFILLER_46_911 VPWR VGND sg13g2_decap_8
XFILLER_17_112 VPWR VGND sg13g2_decap_4
X_2969__141 VPWR VGND net141 sg13g2_tiehi
XFILLER_18_624 VPWR VGND sg13g2_fill_1
XFILLER_18_635 VPWR VGND sg13g2_decap_8
XFILLER_17_134 VPWR VGND sg13g2_fill_1
XFILLER_46_988 VPWR VGND sg13g2_decap_8
XFILLER_45_487 VPWR VGND sg13g2_decap_4
XFILLER_14_852 VPWR VGND sg13g2_decap_8
XFILLER_41_682 VPWR VGND sg13g2_decap_8
XFILLER_40_170 VPWR VGND sg13g2_decap_8
XFILLER_9_366 VPWR VGND sg13g2_decap_8
XFILLER_12_1024 VPWR VGND sg13g2_decap_4
X_2550_ _0922_ net400 _0046_ VPWR VGND sg13g2_nor2b_1
X_2481_ _0863_ _0877_ _0878_ VPWR VGND sg13g2_nor2_1
XFILLER_5_583 VPWR VGND sg13g2_decap_8
X_1501_ _1186_ VPWR _1187_ VGND _1020_ _1029_ sg13g2_o21ai_1
XFILLER_37_922 VPWR VGND sg13g2_decap_8
XFILLER_37_999 VPWR VGND sg13g2_decap_8
XFILLER_36_465 VPWR VGND sg13g2_decap_8
XFILLER_36_476 VPWR VGND sg13g2_decap_8
XFILLER_36_487 VPWR VGND sg13g2_fill_1
XFILLER_32_660 VPWR VGND sg13g2_decap_8
XFILLER_20_822 VPWR VGND sg13g2_decap_8
X_2817_ _1149_ VPWR _1155_ VGND _1151_ _1153_ sg13g2_o21ai_1
X_2748_ _1087_ _1086_ _1015_ VPWR VGND sg13g2_nand2b_1
X_2679_ net335 net339 _1019_ VPWR VGND sg13g2_nor2_2
Xfanout323 _0755_ net323 VPWR VGND sg13g2_buf_8
Xfanout301 net303 net301 VPWR VGND sg13g2_buf_8
Xfanout312 net313 net312 VPWR VGND sg13g2_buf_8
Xfanout356 falutop.alu_data_in\[7\] net356 VPWR VGND sg13g2_buf_8
Xfanout334 falutop.alu_data_in\[14\] net334 VPWR VGND sg13g2_buf_8
Xfanout345 net436 net345 VPWR VGND sg13g2_buf_8
Xfanout389 net391 net389 VPWR VGND sg13g2_buf_8
Xfanout378 net427 net378 VPWR VGND sg13g2_buf_8
Xfanout367 net368 net367 VPWR VGND sg13g2_buf_1
XFILLER_46_229 VPWR VGND sg13g2_fill_2
XFILLER_28_944 VPWR VGND sg13g2_decap_8
XFILLER_36_45 VPWR VGND sg13g2_decap_8
XFILLER_43_969 VPWR VGND sg13g2_decap_8
XFILLER_30_608 VPWR VGND sg13g2_decap_8
XFILLER_23_671 VPWR VGND sg13g2_fill_1
XFILLER_10_332 VPWR VGND sg13g2_decap_4
XFILLER_11_855 VPWR VGND sg13g2_decap_8
XFILLER_10_354 VPWR VGND sg13g2_decap_8
XFILLER_6_314 VPWR VGND sg13g2_decap_8
XFILLER_10_387 VPWR VGND sg13g2_decap_8
XFILLER_7_0 VPWR VGND sg13g2_decap_8
XFILLER_2_553 VPWR VGND sg13g2_decap_8
XFILLER_42_1028 VPWR VGND sg13g2_fill_1
XFILLER_19_933 VPWR VGND sg13g2_decap_8
XFILLER_46_785 VPWR VGND sg13g2_decap_8
XFILLER_45_240 VPWR VGND sg13g2_decap_8
XFILLER_34_936 VPWR VGND sg13g2_decap_8
XFILLER_33_413 VPWR VGND sg13g2_fill_1
XFILLER_21_619 VPWR VGND sg13g2_fill_1
XFILLER_42_991 VPWR VGND sg13g2_decap_8
X_1981_ VGND VPWR _0442_ _0447_ _0457_ _0444_ sg13g2_a21oi_1
XFILLER_14_693 VPWR VGND sg13g2_decap_4
XFILLER_41_490 VPWR VGND sg13g2_decap_8
XFILLER_9_152 VPWR VGND sg13g2_decap_8
XFILLER_9_130 VPWR VGND sg13g2_decap_8
XFILLER_9_163 VPWR VGND sg13g2_fill_2
X_2602_ VGND VPWR _0842_ net313 _0075_ _0945_ sg13g2_a21oi_1
XFILLER_6_881 VPWR VGND sg13g2_decap_8
X_2533_ _0906_ _0907_ _0908_ VPWR VGND _0874_ sg13g2_nand3b_1
XFILLER_5_391 VPWR VGND sg13g2_decap_8
X_2464_ falutop.i2c_inst.counter\[4\] falutop.i2c_inst.counter\[3\] falutop.i2c_inst.counter\[2\]
+ _0862_ VPWR VGND sg13g2_nor3_1
X_2395_ falutop.div_inst.b1\[3\] falutop.div_inst.acc\[3\] _0806_ VPWR VGND sg13g2_nor2b_1
XFILLER_49_590 VPWR VGND sg13g2_decap_8
XFILLER_25_903 VPWR VGND sg13g2_decap_8
XFILLER_36_273 VPWR VGND sg13g2_fill_2
XFILLER_24_446 VPWR VGND sg13g2_decap_8
XFILLER_20_630 VPWR VGND sg13g2_decap_8
XFILLER_22_14 VPWR VGND sg13g2_decap_8
XFILLER_4_818 VPWR VGND sg13g2_decap_8
XFILLER_0_7 VPWR VGND sg13g2_decap_8
XFILLER_47_538 VPWR VGND sg13g2_decap_8
XFILLER_19_218 VPWR VGND sg13g2_fill_2
XFILLER_19_229 VPWR VGND sg13g2_decap_8
XFILLER_47_549 VPWR VGND sg13g2_fill_2
XFILLER_28_752 VPWR VGND sg13g2_decap_4
XFILLER_15_402 VPWR VGND sg13g2_fill_2
XFILLER_16_925 VPWR VGND sg13g2_decap_8
XFILLER_28_774 VPWR VGND sg13g2_decap_8
XFILLER_43_722 VPWR VGND sg13g2_decap_8
XFILLER_27_295 VPWR VGND sg13g2_decap_8
XFILLER_15_446 VPWR VGND sg13g2_decap_8
XFILLER_31_906 VPWR VGND sg13g2_decap_8
XFILLER_8_49 VPWR VGND sg13g2_fill_1
XFILLER_11_652 VPWR VGND sg13g2_decap_8
XFILLER_7_667 VPWR VGND sg13g2_decap_8
XFILLER_6_111 VPWR VGND sg13g2_decap_8
XFILLER_3_851 VPWR VGND sg13g2_decap_8
X_2180_ VGND VPWR net326 net294 _0105_ _0640_ sg13g2_a21oi_1
XFILLER_38_527 VPWR VGND sg13g2_decap_8
XFILLER_19_763 VPWR VGND sg13g2_decap_8
XFILLER_34_733 VPWR VGND sg13g2_fill_1
XFILLER_34_777 VPWR VGND sg13g2_fill_1
XFILLER_21_427 VPWR VGND sg13g2_fill_2
XFILLER_22_928 VPWR VGND sg13g2_decap_8
XFILLER_33_265 VPWR VGND sg13g2_fill_1
XFILLER_34_788 VPWR VGND sg13g2_decap_8
X_1964_ _0441_ _0413_ _0439_ VPWR VGND sg13g2_xnor2_1
XFILLER_30_972 VPWR VGND sg13g2_decap_8
X_1895_ _0369_ _0371_ _0373_ VPWR VGND sg13g2_nor2_1
X_2516_ falutop.i2c_inst.data_in\[5\] falutop.data_in\[5\] net321 _0033_ VPWR VGND
+ sg13g2_mux2_1
X_2447_ _0851_ _0802_ _0821_ VPWR VGND sg13g2_xnor2_1
XFILLER_25_1001 VPWR VGND sg13g2_decap_8
X_2378_ _0734_ net385 _0792_ VPWR VGND sg13g2_nor2_1
XFILLER_29_538 VPWR VGND sg13g2_decap_4
XFILLER_17_25 VPWR VGND sg13g2_decap_8
XFILLER_25_755 VPWR VGND sg13g2_fill_1
XFILLER_40_736 VPWR VGND sg13g2_decap_4
XFILLER_12_449 VPWR VGND sg13g2_fill_1
XFILLER_33_57 VPWR VGND sg13g2_decap_8
XFILLER_20_460 VPWR VGND sg13g2_fill_2
XFILLER_32_1016 VPWR VGND sg13g2_decap_8
XFILLER_32_1027 VPWR VGND sg13g2_fill_2
XFILLER_4_615 VPWR VGND sg13g2_decap_8
XFILLER_3_147 VPWR VGND sg13g2_decap_4
XFILLER_48_836 VPWR VGND sg13g2_decap_8
XFILLER_47_302 VPWR VGND sg13g2_decap_8
XFILLER_0_876 VPWR VGND sg13g2_decap_8
Xhold9 _0003_ VPWR VGND net183 sg13g2_dlygate4sd3_1
XFILLER_47_346 VPWR VGND sg13g2_decap_4
XFILLER_47_357 VPWR VGND sg13g2_decap_8
XFILLER_28_582 VPWR VGND sg13g2_decap_8
XFILLER_43_530 VPWR VGND sg13g2_decap_8
XFILLER_15_265 VPWR VGND sg13g2_fill_1
XFILLER_31_725 VPWR VGND sg13g2_decap_8
XFILLER_30_224 VPWR VGND sg13g2_fill_1
XFILLER_8_921 VPWR VGND sg13g2_decap_8
XFILLER_12_961 VPWR VGND sg13g2_decap_8
XFILLER_30_268 VPWR VGND sg13g2_fill_1
XFILLER_11_482 VPWR VGND sg13g2_decap_8
XFILLER_8_998 VPWR VGND sg13g2_decap_8
XFILLER_7_464 VPWR VGND sg13g2_decap_8
X_1680_ _0160_ _0159_ _0150_ _0162_ VPWR VGND sg13g2_a21o_1
X_2301_ net401 VPWR _0724_ VGND falutop.i2c_inst.data_in\[15\] _0723_ sg13g2_o21ai_1
XFILLER_39_803 VPWR VGND sg13g2_decap_8
X_2232_ _0672_ VPWR _0123_ VGND net299 _0674_ sg13g2_o21ai_1
X_2163_ falutop.data_in\[6\] net300 _0632_ _0633_ VPWR VGND sg13g2_nor3_1
XFILLER_38_368 VPWR VGND sg13g2_decap_8
X_2094_ _0499_ _0500_ _0527_ _0566_ _0568_ VPWR VGND sg13g2_nor4_1
XFILLER_19_582 VPWR VGND sg13g2_decap_4
XFILLER_34_541 VPWR VGND sg13g2_fill_2
XFILLER_21_246 VPWR VGND sg13g2_decap_8
XFILLER_9_70 VPWR VGND sg13g2_decap_8
X_1947_ _0424_ net339 net358 VPWR VGND sg13g2_nand2_1
X_1878_ VGND VPWR _0357_ _0356_ net293 sg13g2_or2_1
XFILLER_28_46 VPWR VGND sg13g2_fill_2
XFILLER_45_828 VPWR VGND sg13g2_decap_8
XFILLER_44_316 VPWR VGND sg13g2_fill_2
XFILLER_44_34 VPWR VGND sg13g2_decap_8
XFILLER_25_530 VPWR VGND sg13g2_decap_8
XFILLER_44_67 VPWR VGND sg13g2_decap_4
XFILLER_44_45 VPWR VGND sg13g2_fill_1
XFILLER_13_703 VPWR VGND sg13g2_decap_8
XFILLER_25_563 VPWR VGND sg13g2_decap_8
XFILLER_9_707 VPWR VGND sg13g2_decap_8
XFILLER_13_758 VPWR VGND sg13g2_decap_8
XFILLER_4_412 VPWR VGND sg13g2_decap_8
XFILLER_5_968 VPWR VGND sg13g2_decap_8
XFILLER_5_39 VPWR VGND sg13g2_fill_2
XFILLER_4_489 VPWR VGND sg13g2_decap_8
XFILLER_0_673 VPWR VGND sg13g2_decap_8
XFILLER_48_644 VPWR VGND sg13g2_fill_1
XFILLER_35_305 VPWR VGND sg13g2_decap_8
XFILLER_47_187 VPWR VGND sg13g2_decap_8
XFILLER_16_530 VPWR VGND sg13g2_decap_8
XFILLER_35_349 VPWR VGND sg13g2_decap_4
XFILLER_44_872 VPWR VGND sg13g2_decap_8
XFILLER_43_382 VPWR VGND sg13g2_decap_8
X_2850_ net95 VGND VPWR net236 falutop.div_inst.acc\[0\] clknet_4_1_0_clk sg13g2_dfrbpq_2
XFILLER_31_566 VPWR VGND sg13g2_decap_8
XFILLER_31_577 VPWR VGND sg13g2_fill_2
X_1801_ _0281_ _0211_ _0279_ VPWR VGND sg13g2_xnor2_1
X_2781_ VPWR VGND _0975_ _1118_ _1119_ _0974_ _1120_ _1051_ sg13g2_a221oi_1
X_1732_ _0213_ _0208_ _0212_ VPWR VGND sg13g2_nand2_1
XFILLER_8_795 VPWR VGND sg13g2_decap_8
X_1663_ net340 net373 net343 _1346_ VPWR VGND net370 sg13g2_nand4_1
X_1594_ _1267_ _1276_ _1278_ VPWR VGND sg13g2_nor2_1
XFILLER_39_633 VPWR VGND sg13g2_decap_8
X_2215_ VGND VPWR net303 _0662_ _0118_ _0660_ sg13g2_a21oi_1
XFILLER_22_1026 VPWR VGND sg13g2_fill_2
XFILLER_27_806 VPWR VGND sg13g2_decap_4
XFILLER_26_327 VPWR VGND sg13g2_decap_4
X_2146_ _0359_ VPWR _0618_ VGND _0985_ net285 sg13g2_o21ai_1
XFILLER_42_809 VPWR VGND sg13g2_decap_8
X_2077_ _0551_ net324 net356 VPWR VGND sg13g2_nand2_1
XFILLER_41_319 VPWR VGND sg13g2_decap_8
XFILLER_22_577 VPWR VGND sg13g2_decap_8
X_2979_ net103 VGND VPWR _0136_ falutop.i2c_inst.data_in\[8\] net393 sg13g2_dfrbpq_1
XFILLER_30_58 VPWR VGND sg13g2_decap_4
XFILLER_2_938 VPWR VGND sg13g2_decap_8
XFILLER_1_448 VPWR VGND sg13g2_decap_8
XFILLER_29_143 VPWR VGND sg13g2_decap_8
XFILLER_18_828 VPWR VGND sg13g2_decap_8
XFILLER_45_647 VPWR VGND sg13g2_decap_4
XFILLER_33_809 VPWR VGND sg13g2_decap_8
XFILLER_26_861 VPWR VGND sg13g2_decap_4
XFILLER_25_393 VPWR VGND sg13g2_decap_8
XFILLER_9_504 VPWR VGND sg13g2_decap_8
XFILLER_13_577 VPWR VGND sg13g2_decap_8
XFILLER_5_765 VPWR VGND sg13g2_decap_8
X_2898__174 VPWR VGND net174 sg13g2_tiehi
XFILLER_0_470 VPWR VGND sg13g2_decap_8
XFILLER_49_986 VPWR VGND sg13g2_decap_8
X_2000_ _0476_ _0466_ _0475_ VPWR VGND sg13g2_xnor2_1
XFILLER_36_669 VPWR VGND sg13g2_fill_1
X_2902_ net170 VGND VPWR _0059_ falutop.div_inst.b1\[5\] clknet_4_2_0_clk sg13g2_dfrbpq_2
XFILLER_32_864 VPWR VGND sg13g2_fill_2
X_2833_ _0972_ _0977_ _0971_ _1171_ VPWR VGND sg13g2_nand3_1
XFILLER_31_374 VPWR VGND sg13g2_decap_8
XFILLER_32_897 VPWR VGND sg13g2_decap_8
X_2764_ _1103_ _1100_ _1102_ VPWR VGND sg13g2_nand2_1
XFILLER_8_592 VPWR VGND sg13g2_decap_8
X_1715_ _0196_ net337 net370 VPWR VGND sg13g2_nand2_1
XFILLER_6_60 VPWR VGND sg13g2_fill_2
X_2695_ _1029_ _1034_ _1022_ _1035_ VPWR VGND sg13g2_mux2_1
X_1646_ _1329_ net329 net364 net360 VPWR VGND sg13g2_and3_2
X_1577_ _1262_ _1259_ _1261_ _1258_ net290 VPWR VGND sg13g2_a22oi_1
X_2129_ VGND VPWR _0569_ _0582_ _0602_ _0600_ sg13g2_a21oi_1
XFILLER_26_146 VPWR VGND sg13g2_decap_8
XFILLER_25_25 VPWR VGND sg13g2_decap_8
XFILLER_23_853 VPWR VGND sg13g2_decap_4
XFILLER_23_897 VPWR VGND sg13g2_decap_8
XFILLER_10_547 VPWR VGND sg13g2_decap_8
XFILLER_9_4 VPWR VGND sg13g2_decap_4
XFILLER_2_735 VPWR VGND sg13g2_decap_8
XFILLER_49_205 VPWR VGND sg13g2_decap_8
XFILLER_1_267 VPWR VGND sg13g2_fill_1
XFILLER_2_18 VPWR VGND sg13g2_decap_8
XFILLER_45_400 VPWR VGND sg13g2_fill_2
XFILLER_46_967 VPWR VGND sg13g2_decap_8
XFILLER_14_831 VPWR VGND sg13g2_decap_8
XFILLER_33_639 VPWR VGND sg13g2_decap_8
XFILLER_32_149 VPWR VGND sg13g2_decap_8
XFILLER_13_385 VPWR VGND sg13g2_fill_1
XFILLER_9_345 VPWR VGND sg13g2_fill_2
XFILLER_12_1003 VPWR VGND sg13g2_decap_8
X_2480_ _0877_ _0868_ _0872_ VPWR VGND sg13g2_nand2_2
XFILLER_5_562 VPWR VGND sg13g2_decap_8
X_1500_ _1185_ VPWR _1186_ VGND _0753_ net328 sg13g2_o21ai_1
XFILLER_37_901 VPWR VGND sg13g2_decap_8
XFILLER_49_783 VPWR VGND sg13g2_decap_8
XFILLER_48_260 VPWR VGND sg13g2_fill_1
X_2913__152 VPWR VGND net152 sg13g2_tiehi
XFILLER_37_978 VPWR VGND sg13g2_decap_8
X_2983__117 VPWR VGND net117 sg13g2_tiehi
XFILLER_24_617 VPWR VGND sg13g2_decap_8
XFILLER_16_190 VPWR VGND sg13g2_decap_8
XFILLER_23_149 VPWR VGND sg13g2_decap_8
X_2816_ _1149_ _1151_ _1153_ _1154_ VPWR VGND sg13g2_or3_1
XFILLER_11_49 VPWR VGND sg13g2_fill_1
X_2747_ _1085_ _1084_ _1086_ VPWR VGND sg13g2_xor2_1
X_2678_ _1018_ net324 net323 VPWR VGND sg13g2_nand2_1
X_1629_ _1311_ _1209_ _1313_ VPWR VGND sg13g2_xor2_1
Xfanout302 net303 net302 VPWR VGND sg13g2_buf_1
Xfanout313 net314 net313 VPWR VGND sg13g2_buf_8
XFILLER_28_1021 VPWR VGND sg13g2_decap_8
Xfanout357 net428 net357 VPWR VGND sg13g2_buf_8
Xfanout324 _0754_ net324 VPWR VGND sg13g2_buf_8
Xfanout335 net338 net335 VPWR VGND sg13g2_buf_8
Xfanout346 net347 net346 VPWR VGND sg13g2_buf_8
Xfanout379 falutop.alu_inst.op\[2\] net379 VPWR VGND sg13g2_buf_2
Xfanout368 net432 net368 VPWR VGND sg13g2_buf_8
XFILLER_28_923 VPWR VGND sg13g2_decap_8
XFILLER_27_422 VPWR VGND sg13g2_decap_4
XFILLER_15_617 VPWR VGND sg13g2_fill_2
XFILLER_27_477 VPWR VGND sg13g2_decap_8
XFILLER_43_948 VPWR VGND sg13g2_decap_8
XFILLER_14_138 VPWR VGND sg13g2_fill_2
XFILLER_11_834 VPWR VGND sg13g2_decap_8
XFILLER_23_694 VPWR VGND sg13g2_decap_4
XFILLER_35_1025 VPWR VGND sg13g2_decap_4
XFILLER_10_377 VPWR VGND sg13g2_decap_4
XFILLER_7_849 VPWR VGND sg13g2_decap_8
XFILLER_6_348 VPWR VGND sg13g2_decap_8
XFILLER_2_532 VPWR VGND sg13g2_decap_8
XFILLER_37_219 VPWR VGND sg13g2_decap_8
XFILLER_19_912 VPWR VGND sg13g2_decap_8
XFILLER_18_422 VPWR VGND sg13g2_fill_2
XFILLER_46_764 VPWR VGND sg13g2_decap_8
XFILLER_19_989 VPWR VGND sg13g2_decap_8
XFILLER_34_915 VPWR VGND sg13g2_decap_8
XFILLER_45_274 VPWR VGND sg13g2_decap_4
X_1980_ _0455_ _0456_ _0089_ VPWR VGND sg13g2_nor2_1
XFILLER_42_970 VPWR VGND sg13g2_decap_8
XFILLER_14_661 VPWR VGND sg13g2_decap_8
XFILLER_13_182 VPWR VGND sg13g2_decap_8
X_2601_ net405 VPWR _0945_ VGND net413 net312 sg13g2_o21ai_1
X_2954__33 VPWR VGND net33 sg13g2_tiehi
XFILLER_6_860 VPWR VGND sg13g2_decap_8
X_2532_ _0907_ _0902_ falutop.i2c_inst.result\[2\] _0883_ falutop.i2c_inst.result\[0\]
+ VPWR VGND sg13g2_a22oi_1
X_2463_ falutop.i2c_inst.counter\[4\] falutop.i2c_inst.counter\[3\] _0861_ VPWR VGND
+ sg13g2_nor2_1
X_2394_ falutop.div_inst.b1\[4\] falutop.div_inst.acc\[4\] _0805_ VPWR VGND sg13g2_nor2b_1
XFILLER_3_61 VPWR VGND sg13g2_decap_8
XFILLER_3_1012 VPWR VGND sg13g2_decap_8
XFILLER_28_219 VPWR VGND sg13g2_decap_4
XFILLER_37_742 VPWR VGND sg13g2_decap_8
XFILLER_37_753 VPWR VGND sg13g2_fill_2
XFILLER_36_241 VPWR VGND sg13g2_fill_1
XFILLER_37_797 VPWR VGND sg13g2_decap_8
XFILLER_25_959 VPWR VGND sg13g2_decap_8
XFILLER_12_609 VPWR VGND sg13g2_decap_4
XFILLER_33_981 VPWR VGND sg13g2_decap_8
XFILLER_47_517 VPWR VGND sg13g2_decap_8
XFILLER_43_701 VPWR VGND sg13g2_decap_8
XFILLER_16_904 VPWR VGND sg13g2_decap_8
XFILLER_42_211 VPWR VGND sg13g2_fill_2
XFILLER_27_285 VPWR VGND sg13g2_decap_4
XFILLER_42_244 VPWR VGND sg13g2_decap_4
XFILLER_8_39 VPWR VGND sg13g2_fill_1
XFILLER_8_28 VPWR VGND sg13g2_decap_8
XFILLER_11_631 VPWR VGND sg13g2_decap_8
XFILLER_10_152 VPWR VGND sg13g2_fill_2
XFILLER_10_141 VPWR VGND sg13g2_decap_8
XFILLER_10_174 VPWR VGND sg13g2_fill_1
XFILLER_7_646 VPWR VGND sg13g2_decap_8
XFILLER_6_178 VPWR VGND sg13g2_decap_4
XFILLER_3_830 VPWR VGND sg13g2_decap_8
X_2973__127 VPWR VGND net127 sg13g2_tiehi
XFILLER_38_539 VPWR VGND sg13g2_decap_4
XFILLER_19_797 VPWR VGND sg13g2_decap_4
XFILLER_22_907 VPWR VGND sg13g2_decap_8
XFILLER_21_406 VPWR VGND sg13g2_decap_8
X_1963_ _0440_ _0413_ _0439_ VPWR VGND sg13g2_nand2_1
XFILLER_30_951 VPWR VGND sg13g2_decap_8
X_1894_ _0372_ _0369_ _0371_ VPWR VGND sg13g2_nand2_1
X_2515_ falutop.i2c_inst.data_in\[4\] falutop.data_in\[4\] net321 _0032_ VPWR VGND
+ sg13g2_mux2_1
X_2446_ _0847_ VPWR _0014_ VGND _0768_ _0850_ sg13g2_o21ai_1
X_2377_ VGND VPWR net287 _0790_ _0004_ _0791_ sg13g2_a21oi_1
XFILLER_44_509 VPWR VGND sg13g2_fill_1
XFILLER_25_701 VPWR VGND sg13g2_decap_8
XFILLER_37_572 VPWR VGND sg13g2_decap_8
XFILLER_17_48 VPWR VGND sg13g2_fill_1
XFILLER_24_211 VPWR VGND sg13g2_decap_8
XFILLER_24_266 VPWR VGND sg13g2_decap_8
XFILLER_24_277 VPWR VGND sg13g2_fill_2
XFILLER_20_483 VPWR VGND sg13g2_fill_2
XFILLER_21_995 VPWR VGND sg13g2_decap_8
XFILLER_0_855 VPWR VGND sg13g2_decap_8
XFILLER_48_815 VPWR VGND sg13g2_decap_8
XFILLER_16_734 VPWR VGND sg13g2_decap_8
XFILLER_28_561 VPWR VGND sg13g2_decap_8
XFILLER_15_233 VPWR VGND sg13g2_decap_8
XFILLER_16_756 VPWR VGND sg13g2_decap_8
XFILLER_16_789 VPWR VGND sg13g2_decap_8
XFILLER_12_940 VPWR VGND sg13g2_decap_8
XFILLER_15_288 VPWR VGND sg13g2_decap_8
XFILLER_31_759 VPWR VGND sg13g2_fill_2
XFILLER_8_900 VPWR VGND sg13g2_decap_8
XFILLER_11_450 VPWR VGND sg13g2_decap_8
XFILLER_11_461 VPWR VGND sg13g2_fill_2
XFILLER_23_80 VPWR VGND sg13g2_decap_4
XFILLER_8_977 VPWR VGND sg13g2_decap_8
XFILLER_11_494 VPWR VGND sg13g2_decap_8
X_2300_ _0685_ _0716_ _0723_ VPWR VGND sg13g2_nor2_1
XFILLER_2_181 VPWR VGND sg13g2_decap_8
X_2231_ _0674_ falutop.data_in\[11\] _0673_ VPWR VGND sg13g2_xnor2_1
XFILLER_24_4 VPWR VGND sg13g2_fill_2
X_2162_ _0632_ _0631_ falutop.data_in\[5\] VPWR VGND sg13g2_nand2b_1
X_2093_ _0567_ _0526_ _0566_ VPWR VGND sg13g2_nand2_1
XFILLER_19_561 VPWR VGND sg13g2_decap_8
XFILLER_0_84 VPWR VGND sg13g2_decap_8
XFILLER_22_759 VPWR VGND sg13g2_fill_1
X_1946_ VGND VPWR _0209_ _0384_ _0423_ _0383_ sg13g2_a21oi_1
X_1877_ _0356_ _0320_ _0355_ VPWR VGND sg13g2_xnor2_1
X_2429_ _0837_ net282 _0836_ VPWR VGND sg13g2_nand2_1
XFILLER_28_25 VPWR VGND sg13g2_decap_8
XFILLER_45_807 VPWR VGND sg13g2_decap_8
XFILLER_44_13 VPWR VGND sg13g2_decap_8
XFILLER_25_586 VPWR VGND sg13g2_fill_1
XFILLER_40_534 VPWR VGND sg13g2_decap_8
XFILLER_12_225 VPWR VGND sg13g2_fill_1
XFILLER_40_556 VPWR VGND sg13g2_decap_8
XFILLER_8_207 VPWR VGND sg13g2_decap_8
XFILLER_12_269 VPWR VGND sg13g2_decap_8
XFILLER_20_280 VPWR VGND sg13g2_decap_8
XFILLER_5_947 VPWR VGND sg13g2_decap_8
XFILLER_5_18 VPWR VGND sg13g2_decap_8
XFILLER_4_468 VPWR VGND sg13g2_decap_8
XFILLER_0_652 VPWR VGND sg13g2_decap_8
XFILLER_48_623 VPWR VGND sg13g2_fill_2
XFILLER_47_100 VPWR VGND sg13g2_decap_8
XFILLER_47_155 VPWR VGND sg13g2_decap_4
XFILLER_47_133 VPWR VGND sg13g2_decap_8
XFILLER_36_807 VPWR VGND sg13g2_fill_1
XFILLER_48_689 VPWR VGND sg13g2_decap_8
XFILLER_47_166 VPWR VGND sg13g2_fill_2
XFILLER_29_881 VPWR VGND sg13g2_decap_8
XFILLER_44_851 VPWR VGND sg13g2_decap_8
XFILLER_16_597 VPWR VGND sg13g2_decap_8
XFILLER_31_512 VPWR VGND sg13g2_fill_1
X_1800_ _0211_ _0279_ _0280_ VPWR VGND sg13g2_nor2b_1
X_2780_ falutop.alu_inst.op\[0\] _1053_ _1119_ VPWR VGND sg13g2_nor2_2
XFILLER_8_774 VPWR VGND sg13g2_decap_8
XFILLER_11_291 VPWR VGND sg13g2_decap_8
X_1731_ _0210_ _0964_ _0212_ VPWR VGND sg13g2_xor2_1
X_1662_ net344 net340 net373 net369 _1345_ VPWR VGND sg13g2_and4_1
X_1593_ _1277_ _1267_ _1276_ VPWR VGND sg13g2_nand2_1
X_2214_ _0662_ falutop.data_in\[5\] _0661_ VPWR VGND sg13g2_xnor2_1
XFILLER_22_1005 VPWR VGND sg13g2_decap_8
X_2145_ net292 _0598_ _0602_ _0616_ _0617_ VPWR VGND sg13g2_nor4_1
XFILLER_39_689 VPWR VGND sg13g2_decap_8
XFILLER_27_829 VPWR VGND sg13g2_decap_8
X_2076_ _0550_ net331 net358 VPWR VGND sg13g2_nand2_1
XFILLER_19_391 VPWR VGND sg13g2_decap_8
XFILLER_22_534 VPWR VGND sg13g2_decap_8
XFILLER_22_556 VPWR VGND sg13g2_decap_8
X_2978_ net107 VGND VPWR _0135_ falutop.i2c_inst.data_in\[7\] net396 sg13g2_dfrbpq_1
XFILLER_10_729 VPWR VGND sg13g2_decap_8
X_2923__132 VPWR VGND net132 sg13g2_tiehi
X_1929_ net291 VPWR _0407_ VGND _0403_ _0406_ sg13g2_o21ai_1
XFILLER_2_917 VPWR VGND sg13g2_decap_8
XFILLER_1_427 VPWR VGND sg13g2_decap_8
XFILLER_29_100 VPWR VGND sg13g2_decap_8
XFILLER_29_122 VPWR VGND sg13g2_decap_8
XFILLER_17_317 VPWR VGND sg13g2_decap_8
XFILLER_45_659 VPWR VGND sg13g2_decap_8
XFILLER_29_199 VPWR VGND sg13g2_decap_8
XFILLER_38_1023 VPWR VGND sg13g2_decap_4
XFILLER_41_843 VPWR VGND sg13g2_fill_2
XFILLER_25_372 VPWR VGND sg13g2_decap_8
XFILLER_13_545 VPWR VGND sg13g2_fill_2
XFILLER_13_556 VPWR VGND sg13g2_decap_8
XFILLER_41_898 VPWR VGND sg13g2_decap_8
XFILLER_5_744 VPWR VGND sg13g2_decap_8
XFILLER_4_210 VPWR VGND sg13g2_fill_2
XFILLER_20_70 VPWR VGND sg13g2_fill_2
XFILLER_20_81 VPWR VGND sg13g2_decap_8
XFILLER_20_92 VPWR VGND sg13g2_fill_1
XFILLER_1_994 VPWR VGND sg13g2_decap_8
XFILLER_49_965 VPWR VGND sg13g2_decap_8
Xhold90 falutop.i2c_inst.result\[6\] VPWR VGND net264 sg13g2_dlygate4sd3_1
XFILLER_17_884 VPWR VGND sg13g2_decap_8
XFILLER_23_309 VPWR VGND sg13g2_fill_2
XFILLER_35_169 VPWR VGND sg13g2_decap_8
XFILLER_44_692 VPWR VGND sg13g2_decap_8
X_2901_ net171 VGND VPWR _0058_ falutop.div_inst.b1\[4\] clknet_4_2_0_clk sg13g2_dfrbpq_1
XFILLER_16_383 VPWR VGND sg13g2_fill_2
XFILLER_16_394 VPWR VGND sg13g2_decap_8
XFILLER_31_353 VPWR VGND sg13g2_decap_8
X_2832_ _1169_ VPWR _1170_ VGND _1112_ _1167_ sg13g2_o21ai_1
X_2763_ net335 net352 net372 _1102_ VPWR VGND sg13g2_a21o_1
XFILLER_8_571 VPWR VGND sg13g2_decap_8
X_1714_ _0152_ _0154_ _0195_ VPWR VGND sg13g2_nor2b_1
X_2694_ _1033_ VPWR _1034_ VGND _0749_ _1027_ sg13g2_o21ai_1
X_1645_ net349 net360 _1328_ VPWR VGND sg13g2_and2_1
X_1576_ net316 _1260_ _1261_ VPWR VGND sg13g2_and2_1
XFILLER_6_1021 VPWR VGND sg13g2_decap_8
XFILLER_39_453 VPWR VGND sg13g2_fill_1
XFILLER_27_626 VPWR VGND sg13g2_decap_4
X_2128_ _0565_ _0568_ _0570_ _0599_ _0601_ VPWR VGND sg13g2_nor4_1
XFILLER_27_637 VPWR VGND sg13g2_decap_8
XFILLER_27_648 VPWR VGND sg13g2_fill_1
X_2059_ VGND VPWR _0533_ _0534_ _0530_ _1069_ sg13g2_a21oi_2
XFILLER_23_832 VPWR VGND sg13g2_decap_8
XFILLER_23_876 VPWR VGND sg13g2_decap_8
XFILLER_41_25 VPWR VGND sg13g2_decap_8
XFILLER_41_69 VPWR VGND sg13g2_fill_1
XFILLER_2_714 VPWR VGND sg13g2_decap_8
XFILLER_1_202 VPWR VGND sg13g2_fill_2
XFILLER_18_615 VPWR VGND sg13g2_decap_8
XFILLER_46_946 VPWR VGND sg13g2_decap_8
XFILLER_45_434 VPWR VGND sg13g2_decap_8
XFILLER_14_810 VPWR VGND sg13g2_decap_8
XFILLER_32_106 VPWR VGND sg13g2_fill_1
XFILLER_13_342 VPWR VGND sg13g2_fill_2
XFILLER_9_324 VPWR VGND sg13g2_decap_8
XFILLER_14_887 VPWR VGND sg13g2_decap_8
XFILLER_15_92 VPWR VGND sg13g2_decap_8
XFILLER_13_397 VPWR VGND sg13g2_decap_8
XFILLER_5_541 VPWR VGND sg13g2_decap_8
XFILLER_1_791 VPWR VGND sg13g2_decap_8
XFILLER_49_762 VPWR VGND sg13g2_decap_8
XFILLER_36_401 VPWR VGND sg13g2_decap_8
XFILLER_37_957 VPWR VGND sg13g2_decap_8
XFILLER_23_106 VPWR VGND sg13g2_decap_8
XFILLER_23_128 VPWR VGND sg13g2_decap_8
XFILLER_32_640 VPWR VGND sg13g2_decap_8
X_2815_ VGND VPWR net354 net333 _1153_ net369 sg13g2_a21oi_1
X_2746_ VGND VPWR _1001_ _1010_ _1085_ _1009_ sg13g2_a21oi_1
X_2677_ net334 net328 _1017_ VPWR VGND sg13g2_nor2_2
X_1628_ _1209_ _1311_ _1312_ VPWR VGND sg13g2_nor2_1
XFILLER_28_1000 VPWR VGND sg13g2_decap_8
Xfanout314 _0921_ net314 VPWR VGND sg13g2_buf_8
Xfanout303 _0900_ net303 VPWR VGND sg13g2_buf_8
X_1559_ _1240_ _1241_ _1243_ _1244_ VPWR VGND sg13g2_or3_1
Xfanout347 net348 net347 VPWR VGND sg13g2_buf_8
Xfanout336 net338 net336 VPWR VGND sg13g2_buf_8
Xfanout325 _0750_ net325 VPWR VGND sg13g2_buf_8
Xfanout358 net359 net358 VPWR VGND sg13g2_buf_8
Xfanout369 net370 net369 VPWR VGND sg13g2_buf_8
XFILLER_28_902 VPWR VGND sg13g2_decap_8
XFILLER_43_927 VPWR VGND sg13g2_decap_8
XFILLER_15_607 VPWR VGND sg13g2_fill_2
XFILLER_28_979 VPWR VGND sg13g2_decap_8
XFILLER_35_1004 VPWR VGND sg13g2_decap_8
XFILLER_11_813 VPWR VGND sg13g2_decap_8
XFILLER_7_828 VPWR VGND sg13g2_decap_8
XFILLER_6_327 VPWR VGND sg13g2_decap_8
XFILLER_2_511 VPWR VGND sg13g2_decap_8
XFILLER_2_588 VPWR VGND sg13g2_decap_8
XFILLER_42_1019 VPWR VGND sg13g2_decap_8
XFILLER_18_401 VPWR VGND sg13g2_decap_8
XFILLER_46_743 VPWR VGND sg13g2_decap_8
XFILLER_19_968 VPWR VGND sg13g2_decap_8
XFILLER_18_456 VPWR VGND sg13g2_fill_2
XFILLER_18_478 VPWR VGND sg13g2_decap_8
XFILLER_13_161 VPWR VGND sg13g2_decap_8
XFILLER_9_198 VPWR VGND sg13g2_decap_4
XFILLER_10_890 VPWR VGND sg13g2_decap_8
X_2600_ VGND VPWR _0838_ net313 _0074_ _0944_ sg13g2_a21oi_1
X_2531_ _0906_ _0882_ falutop.i2c_inst.result\[1\] _0872_ falutop.i2c_inst.result\[3\]
+ VPWR VGND sg13g2_a22oi_1
X_2462_ falutop.i2c_inst.state\[1\] _0860_ _0020_ VPWR VGND sg13g2_nor2_1
X_2393_ falutop.div_inst.b1\[5\] falutop.div_inst.acc\[5\] _0804_ VPWR VGND sg13g2_nor2b_1
XFILLER_37_776 VPWR VGND sg13g2_decap_8
XFILLER_24_426 VPWR VGND sg13g2_fill_1
XFILLER_25_938 VPWR VGND sg13g2_decap_8
XFILLER_36_275 VPWR VGND sg13g2_fill_1
XFILLER_40_919 VPWR VGND sg13g2_decap_8
XFILLER_36_297 VPWR VGND sg13g2_decap_8
XFILLER_11_109 VPWR VGND sg13g2_decap_8
XFILLER_33_960 VPWR VGND sg13g2_decap_8
XFILLER_32_492 VPWR VGND sg13g2_decap_8
XFILLER_20_665 VPWR VGND sg13g2_fill_2
XFILLER_20_698 VPWR VGND sg13g2_decap_8
X_2729_ _0992_ _1012_ _1069_ VPWR VGND sg13g2_nor2_2
XFILLER_47_79 VPWR VGND sg13g2_decap_8
XFILLER_28_710 VPWR VGND sg13g2_decap_8
XFILLER_15_404 VPWR VGND sg13g2_fill_1
XFILLER_42_223 VPWR VGND sg13g2_decap_8
XFILLER_24_982 VPWR VGND sg13g2_decap_8
XFILLER_30_407 VPWR VGND sg13g2_decap_8
XFILLER_8_18 VPWR VGND sg13g2_decap_4
XFILLER_11_610 VPWR VGND sg13g2_decap_8
XFILLER_7_625 VPWR VGND sg13g2_decap_8
XFILLER_10_164 VPWR VGND sg13g2_decap_4
XFILLER_6_102 VPWR VGND sg13g2_fill_1
XFILLER_11_687 VPWR VGND sg13g2_decap_8
XFILLER_3_886 VPWR VGND sg13g2_decap_8
XFILLER_2_385 VPWR VGND sg13g2_decap_8
XFILLER_18_242 VPWR VGND sg13g2_fill_2
XFILLER_19_743 VPWR VGND sg13g2_fill_1
XFILLER_19_776 VPWR VGND sg13g2_decap_8
XFILLER_46_595 VPWR VGND sg13g2_decap_8
XFILLER_46_573 VPWR VGND sg13g2_decap_8
XFILLER_15_982 VPWR VGND sg13g2_decap_8
XFILLER_18_1010 VPWR VGND sg13g2_decap_8
X_1962_ _0437_ _0414_ _0439_ VPWR VGND sg13g2_xor2_1
XFILLER_21_429 VPWR VGND sg13g2_fill_1
XFILLER_30_930 VPWR VGND sg13g2_decap_8
X_1893_ VGND VPWR net371 _0261_ _0371_ net327 sg13g2_a21oi_1
XFILLER_45_0 VPWR VGND sg13g2_decap_4
X_2514_ falutop.i2c_inst.data_in\[3\] falutop.data_in\[3\] net320 _0031_ VPWR VGND
+ sg13g2_mux2_1
X_2445_ _0849_ VPWR _0850_ VGND net207 net283 sg13g2_o21ai_1
X_2376_ net192 net288 _0791_ VPWR VGND sg13g2_nor2_1
XFILLER_25_735 VPWR VGND sg13g2_decap_8
XFILLER_25_746 VPWR VGND sg13g2_fill_1
XFILLER_40_705 VPWR VGND sg13g2_fill_2
XFILLER_12_418 VPWR VGND sg13g2_fill_2
XFILLER_13_919 VPWR VGND sg13g2_decap_8
XFILLER_21_974 VPWR VGND sg13g2_decap_8
X_2933__112 VPWR VGND net112 sg13g2_tiehi
XFILLER_0_834 VPWR VGND sg13g2_decap_8
XFILLER_16_713 VPWR VGND sg13g2_fill_2
X_2854__88 VPWR VGND net88 sg13g2_tiehi
XFILLER_15_256 VPWR VGND sg13g2_decap_8
XFILLER_31_705 VPWR VGND sg13g2_fill_1
XFILLER_43_598 VPWR VGND sg13g2_fill_2
XFILLER_30_215 VPWR VGND sg13g2_decap_8
XFILLER_31_738 VPWR VGND sg13g2_decap_8
XFILLER_8_956 VPWR VGND sg13g2_decap_8
XFILLER_12_996 VPWR VGND sg13g2_decap_8
XFILLER_7_499 VPWR VGND sg13g2_decap_8
XFILLER_48_1025 VPWR VGND sg13g2_decap_4
XFILLER_3_683 VPWR VGND sg13g2_decap_8
XFILLER_2_160 VPWR VGND sg13g2_decap_8
X_2230_ _0624_ net383 _0673_ VPWR VGND sg13g2_nor2b_1
X_2161_ falutop.data_in\[4\] _0630_ _0631_ VPWR VGND sg13g2_nor2b_1
XFILLER_17_4 VPWR VGND sg13g2_decap_8
X_2092_ _0566_ _0563_ _0564_ VPWR VGND sg13g2_xnor2_1
XFILLER_47_882 VPWR VGND sg13g2_decap_8
XFILLER_0_1016 VPWR VGND sg13g2_decap_8
XFILLER_0_1027 VPWR VGND sg13g2_fill_2
XFILLER_0_63 VPWR VGND sg13g2_decap_8
XFILLER_34_521 VPWR VGND sg13g2_decap_8
XFILLER_34_543 VPWR VGND sg13g2_fill_1
XFILLER_34_598 VPWR VGND sg13g2_decap_4
X_1945_ _0422_ _0263_ _0420_ VPWR VGND sg13g2_xnor2_1
XFILLER_30_782 VPWR VGND sg13g2_decap_8
X_1876_ _0355_ _0321_ _0353_ VPWR VGND sg13g2_xnor2_1
XFILLER_1_609 VPWR VGND sg13g2_decap_8
XFILLER_0_119 VPWR VGND sg13g2_decap_8
X_2428_ _0836_ _0813_ _0814_ VPWR VGND sg13g2_xnor2_1
X_2359_ VGND VPWR net387 falutop.div_inst.a\[0\] _0778_ _0777_ sg13g2_a21oi_1
XFILLER_28_48 VPWR VGND sg13g2_fill_1
XFILLER_29_304 VPWR VGND sg13g2_decap_4
XFILLER_44_329 VPWR VGND sg13g2_decap_8
XFILLER_40_513 VPWR VGND sg13g2_decap_8
XFILLER_25_598 VPWR VGND sg13g2_decap_8
XFILLER_5_926 VPWR VGND sg13g2_decap_8
XFILLER_4_447 VPWR VGND sg13g2_decap_8
XFILLER_0_631 VPWR VGND sg13g2_decap_8
XFILLER_47_112 VPWR VGND sg13g2_decap_8
XFILLER_18_70 VPWR VGND sg13g2_decap_4
XFILLER_44_830 VPWR VGND sg13g2_decap_8
XFILLER_16_565 VPWR VGND sg13g2_decap_8
XFILLER_31_524 VPWR VGND sg13g2_decap_8
XFILLER_31_535 VPWR VGND sg13g2_fill_2
XFILLER_15_1024 VPWR VGND sg13g2_decap_4
XFILLER_8_753 VPWR VGND sg13g2_decap_8
XFILLER_12_793 VPWR VGND sg13g2_decap_8
X_1730_ VGND VPWR _0211_ _0210_ _0964_ sg13g2_or2_1
X_1661_ _1310_ _1302_ _1309_ _1344_ VPWR VGND sg13g2_a21o_1
X_1592_ _1276_ _1273_ _1274_ VPWR VGND sg13g2_xnor2_1
XFILLER_3_480 VPWR VGND sg13g2_decap_8
X_2213_ _0631_ net384 _0661_ VPWR VGND sg13g2_nor2b_1
X_2144_ VGND VPWR _0614_ _0615_ _0616_ _0613_ sg13g2_a21oi_1
XFILLER_22_1028 VPWR VGND sg13g2_fill_1
XFILLER_38_156 VPWR VGND sg13g2_fill_1
X_2075_ VPWR _0549_ _0548_ VGND sg13g2_inv_1
XFILLER_35_852 VPWR VGND sg13g2_decap_8
XFILLER_35_885 VPWR VGND sg13g2_decap_8
XFILLER_22_513 VPWR VGND sg13g2_decap_8
XFILLER_10_708 VPWR VGND sg13g2_decap_8
X_2977_ net111 VGND VPWR _0134_ falutop.i2c_inst.data_in\[6\] net397 sg13g2_dfrbpq_1
X_1928_ _0406_ _0359_ _0405_ VPWR VGND sg13g2_nand2_1
X_1859_ VPWR _0338_ _0337_ VGND sg13g2_inv_1
XFILLER_1_406 VPWR VGND sg13g2_decap_8
XFILLER_45_616 VPWR VGND sg13g2_fill_2
XFILLER_29_178 VPWR VGND sg13g2_decap_8
XFILLER_44_137 VPWR VGND sg13g2_decap_8
XFILLER_26_841 VPWR VGND sg13g2_decap_8
XFILLER_38_1002 VPWR VGND sg13g2_decap_8
XFILLER_25_351 VPWR VGND sg13g2_decap_8
XFILLER_41_822 VPWR VGND sg13g2_decap_4
XFILLER_13_524 VPWR VGND sg13g2_decap_8
XFILLER_26_896 VPWR VGND sg13g2_decap_8
XFILLER_41_877 VPWR VGND sg13g2_decap_8
XFILLER_40_365 VPWR VGND sg13g2_decap_8
XFILLER_9_539 VPWR VGND sg13g2_decap_8
XFILLER_5_723 VPWR VGND sg13g2_decap_8
XFILLER_4_233 VPWR VGND sg13g2_decap_8
XFILLER_4_222 VPWR VGND sg13g2_decap_8
XFILLER_45_1017 VPWR VGND sg13g2_decap_8
XFILLER_45_1028 VPWR VGND sg13g2_fill_1
XFILLER_49_944 VPWR VGND sg13g2_decap_8
XFILLER_48_410 VPWR VGND sg13g2_fill_1
XFILLER_1_973 VPWR VGND sg13g2_decap_8
XFILLER_48_421 VPWR VGND sg13g2_fill_2
Xhold91 falutop.div_inst.b1\[4\] VPWR VGND net265 sg13g2_dlygate4sd3_1
Xhold80 falutop.div_inst.b1\[5\] VPWR VGND net254 sg13g2_dlygate4sd3_1
XFILLER_36_616 VPWR VGND sg13g2_decap_4
XFILLER_17_863 VPWR VGND sg13g2_decap_8
XFILLER_35_148 VPWR VGND sg13g2_decap_8
XFILLER_44_671 VPWR VGND sg13g2_decap_8
XFILLER_43_170 VPWR VGND sg13g2_decap_8
X_2900_ net172 VGND VPWR _0057_ falutop.div_inst.b1\[3\] clknet_4_0_0_clk sg13g2_dfrbpq_2
XFILLER_32_811 VPWR VGND sg13g2_decap_8
XFILLER_32_866 VPWR VGND sg13g2_fill_1
X_2831_ net292 _1168_ _1169_ VPWR VGND sg13g2_nor2_1
X_2762_ VGND VPWR net354 net335 _1101_ net372 sg13g2_a21oi_1
XFILLER_8_550 VPWR VGND sg13g2_decap_8
X_1713_ _0159_ _0161_ _0194_ VPWR VGND sg13g2_and2_1
X_2693_ _1033_ net352 net284 VPWR VGND sg13g2_nand2_1
XFILLER_6_84 VPWR VGND sg13g2_decap_8
X_1644_ _1327_ _1272_ _1275_ VPWR VGND sg13g2_nand2_1
X_1575_ _1134_ _1194_ net215 _1260_ VPWR VGND sg13g2_nand3_1
X_2897__28 VPWR VGND net28 sg13g2_tiehi
XFILLER_6_1000 VPWR VGND sg13g2_decap_8
X_2127_ VPWR _0600_ _0599_ VGND sg13g2_inv_1
X_2058_ _0533_ _0359_ _0532_ VPWR VGND sg13g2_nand2b_1
XFILLER_23_811 VPWR VGND sg13g2_decap_8
XFILLER_22_332 VPWR VGND sg13g2_decap_4
XFILLER_34_181 VPWR VGND sg13g2_decap_8
XFILLER_41_37 VPWR VGND sg13g2_decap_4
XFILLER_41_59 VPWR VGND sg13g2_decap_4
XFILLER_46_925 VPWR VGND sg13g2_decap_8
XFILLER_45_402 VPWR VGND sg13g2_fill_1
XFILLER_17_104 VPWR VGND sg13g2_decap_4
XFILLER_18_649 VPWR VGND sg13g2_decap_8
XFILLER_26_682 VPWR VGND sg13g2_fill_2
XFILLER_41_652 VPWR VGND sg13g2_fill_1
XFILLER_41_641 VPWR VGND sg13g2_decap_8
XFILLER_14_866 VPWR VGND sg13g2_decap_8
XFILLER_25_192 VPWR VGND sg13g2_fill_1
XFILLER_13_354 VPWR VGND sg13g2_fill_2
XFILLER_41_696 VPWR VGND sg13g2_decap_8
XFILLER_40_184 VPWR VGND sg13g2_decap_8
XFILLER_9_347 VPWR VGND sg13g2_fill_1
X_2976__115 VPWR VGND net115 sg13g2_tiehi
XFILLER_5_520 VPWR VGND sg13g2_decap_8
XFILLER_31_92 VPWR VGND sg13g2_decap_8
XFILLER_49_7 VPWR VGND sg13g2_decap_8
XFILLER_5_597 VPWR VGND sg13g2_decap_8
XFILLER_1_770 VPWR VGND sg13g2_decap_8
XFILLER_49_741 VPWR VGND sg13g2_decap_8
XFILLER_0_291 VPWR VGND sg13g2_decap_8
XFILLER_37_936 VPWR VGND sg13g2_decap_8
XFILLER_36_413 VPWR VGND sg13g2_decap_4
XFILLER_32_674 VPWR VGND sg13g2_decap_4
X_2814_ net333 net369 net354 _1152_ VPWR VGND sg13g2_nand3_1
XFILLER_20_847 VPWR VGND sg13g2_decap_8
XFILLER_31_173 VPWR VGND sg13g2_fill_2
XFILLER_11_18 VPWR VGND sg13g2_fill_2
X_2745_ _1084_ _1083_ _1082_ VPWR VGND sg13g2_nand2b_1
X_2676_ _1016_ _0955_ _1011_ VPWR VGND sg13g2_xnor2_1
X_1627_ _1311_ _1302_ _1310_ VPWR VGND sg13g2_xnor2_1
Xfanout304 net306 net304 VPWR VGND sg13g2_buf_8
X_1558_ VGND VPWR net353 net330 _1243_ net366 sg13g2_a21oi_1
Xfanout315 _0897_ net315 VPWR VGND sg13g2_buf_8
Xfanout326 _0748_ net326 VPWR VGND sg13g2_buf_8
Xfanout348 net431 net348 VPWR VGND sg13g2_buf_8
Xfanout337 net338 net337 VPWR VGND sg13g2_buf_8
Xfanout359 net434 net359 VPWR VGND sg13g2_buf_8
XFILLER_28_958 VPWR VGND sg13g2_decap_8
XFILLER_43_906 VPWR VGND sg13g2_decap_8
XFILLER_23_663 VPWR VGND sg13g2_fill_2
XFILLER_7_807 VPWR VGND sg13g2_decap_8
XFILLER_10_368 VPWR VGND sg13g2_decap_4
XFILLER_11_869 VPWR VGND sg13g2_decap_8
XFILLER_2_567 VPWR VGND sg13g2_decap_8
XFILLER_46_722 VPWR VGND sg13g2_decap_8
XFILLER_18_424 VPWR VGND sg13g2_fill_1
XFILLER_19_947 VPWR VGND sg13g2_decap_8
XFILLER_45_254 VPWR VGND sg13g2_fill_1
XFILLER_46_799 VPWR VGND sg13g2_decap_8
XFILLER_27_980 VPWR VGND sg13g2_decap_8
XFILLER_14_641 VPWR VGND sg13g2_fill_1
XFILLER_41_460 VPWR VGND sg13g2_decap_4
X_2530_ _0903_ _0904_ _0874_ _0905_ VPWR VGND sg13g2_nand3_1
X_2461_ net401 VPWR _0860_ VGND falutop.i2c_inst.state\[0\] _0859_ sg13g2_o21ai_1
XFILLER_6_895 VPWR VGND sg13g2_decap_8
XFILLER_5_361 VPWR VGND sg13g2_decap_4
X_2392_ falutop.div_inst.b1\[6\] falutop.div_inst.acc\[6\] _0803_ VPWR VGND sg13g2_nor2b_1
XFILLER_49_571 VPWR VGND sg13g2_fill_1
XFILLER_25_917 VPWR VGND sg13g2_decap_8
XFILLER_36_221 VPWR VGND sg13g2_decap_4
XFILLER_24_405 VPWR VGND sg13g2_fill_2
XFILLER_36_254 VPWR VGND sg13g2_decap_4
XFILLER_20_644 VPWR VGND sg13g2_decap_8
XFILLER_20_677 VPWR VGND sg13g2_fill_2
XFILLER_3_309 VPWR VGND sg13g2_fill_2
X_2728_ VGND VPWR _1068_ _1067_ _1062_ sg13g2_or2_1
X_2659_ net353 net376 _0999_ VPWR VGND sg13g2_and2_1
XFILLER_47_14 VPWR VGND sg13g2_decap_8
XFILLER_47_58 VPWR VGND sg13g2_decap_8
XFILLER_28_733 VPWR VGND sg13g2_decap_8
XFILLER_43_736 VPWR VGND sg13g2_decap_8
XFILLER_15_416 VPWR VGND sg13g2_decap_8
XFILLER_16_939 VPWR VGND sg13g2_decap_8
X_2966__147 VPWR VGND net147 sg13g2_tiehi
XFILLER_28_788 VPWR VGND sg13g2_decap_8
XFILLER_42_268 VPWR VGND sg13g2_fill_1
XFILLER_24_961 VPWR VGND sg13g2_decap_8
XFILLER_23_460 VPWR VGND sg13g2_decap_8
XFILLER_7_604 VPWR VGND sg13g2_decap_8
XFILLER_11_666 VPWR VGND sg13g2_decap_8
XFILLER_6_125 VPWR VGND sg13g2_decap_8
XFILLER_12_50 VPWR VGND sg13g2_decap_8
XFILLER_12_94 VPWR VGND sg13g2_fill_2
XFILLER_3_865 VPWR VGND sg13g2_decap_8
XFILLER_2_353 VPWR VGND sg13g2_fill_2
XFILLER_2_364 VPWR VGND sg13g2_decap_8
XFILLER_19_700 VPWR VGND sg13g2_decap_8
XFILLER_19_722 VPWR VGND sg13g2_decap_8
XFILLER_46_552 VPWR VGND sg13g2_fill_1
XFILLER_37_91 VPWR VGND sg13g2_decap_4
XFILLER_18_298 VPWR VGND sg13g2_decap_8
XFILLER_33_235 VPWR VGND sg13g2_fill_2
XFILLER_34_758 VPWR VGND sg13g2_decap_8
XFILLER_15_961 VPWR VGND sg13g2_decap_8
X_1961_ VGND VPWR _0438_ _0437_ _0414_ sg13g2_or2_1
X_1892_ net330 VPWR _0370_ VGND net374 net370 sg13g2_o21ai_1
XFILLER_30_986 VPWR VGND sg13g2_decap_8
X_2513_ falutop.i2c_inst.data_in\[2\] falutop.data_in\[2\] net320 _0030_ VPWR VGND
+ sg13g2_mux2_1
XFILLER_6_692 VPWR VGND sg13g2_decap_8
X_2444_ _0849_ net283 _0848_ VPWR VGND sg13g2_nand2_1
XFILLER_38_0 VPWR VGND sg13g2_decap_8
X_2375_ VGND VPWR net385 net184 _0790_ _0789_ sg13g2_a21oi_1
XFILLER_25_1015 VPWR VGND sg13g2_decap_8
XFILLER_37_541 VPWR VGND sg13g2_decap_4
XFILLER_37_563 VPWR VGND sg13g2_decap_4
X_2848__97 VPWR VGND net97 sg13g2_tiehi
XFILLER_37_596 VPWR VGND sg13g2_decap_8
XFILLER_21_953 VPWR VGND sg13g2_decap_8
XFILLER_20_485 VPWR VGND sg13g2_fill_1
XFILLER_20_496 VPWR VGND sg13g2_decap_8
XFILLER_4_629 VPWR VGND sg13g2_decap_8
XFILLER_3_128 VPWR VGND sg13g2_fill_1
XFILLER_0_813 VPWR VGND sg13g2_decap_8
XFILLER_47_327 VPWR VGND sg13g2_fill_1
XFILLER_47_316 VPWR VGND sg13g2_decap_8
XFILLER_43_544 VPWR VGND sg13g2_decap_8
XFILLER_28_596 VPWR VGND sg13g2_decap_8
XFILLER_43_577 VPWR VGND sg13g2_decap_8
XFILLER_43_555 VPWR VGND sg13g2_fill_2
XFILLER_15_279 VPWR VGND sg13g2_decap_4
XFILLER_24_780 VPWR VGND sg13g2_decap_8
XFILLER_8_935 VPWR VGND sg13g2_decap_8
XFILLER_12_975 VPWR VGND sg13g2_decap_8
XFILLER_7_478 VPWR VGND sg13g2_decap_8
XFILLER_48_1004 VPWR VGND sg13g2_decap_8
XFILLER_3_662 VPWR VGND sg13g2_decap_8
XFILLER_31_7 VPWR VGND sg13g2_decap_8
XFILLER_39_817 VPWR VGND sg13g2_decap_8
XFILLER_24_6 VPWR VGND sg13g2_fill_1
XFILLER_38_327 VPWR VGND sg13g2_decap_8
X_2160_ falutop.data_in\[3\] _0629_ _0630_ VPWR VGND sg13g2_nor2b_1
XFILLER_48_90 VPWR VGND sg13g2_fill_2
X_2091_ _0563_ _0564_ _0565_ VPWR VGND sg13g2_and2_1
XFILLER_47_861 VPWR VGND sg13g2_decap_8
XFILLER_0_42 VPWR VGND sg13g2_decap_8
XFILLER_19_552 VPWR VGND sg13g2_fill_2
XFILLER_34_555 VPWR VGND sg13g2_decap_8
XFILLER_34_577 VPWR VGND sg13g2_decap_8
X_1944_ _0421_ _0262_ _0420_ VPWR VGND sg13g2_nand2_1
X_1875_ _0353_ _0321_ _0354_ VPWR VGND sg13g2_nor2b_1
X_2427_ _0835_ net202 net289 VPWR VGND sg13g2_nand2_1
Xclkbuf_4_15_0_clk clknet_0_clk clknet_4_15_0_clk VPWR VGND sg13g2_buf_8
X_2358_ _0739_ net387 _0777_ VPWR VGND sg13g2_nor2_1
X_2289_ VGND VPWR net389 _0714_ _0139_ _0715_ sg13g2_a21oi_1
XFILLER_38_883 VPWR VGND sg13g2_decap_8
XFILLER_13_717 VPWR VGND sg13g2_decap_8
XFILLER_25_577 VPWR VGND sg13g2_decap_8
XFILLER_12_249 VPWR VGND sg13g2_fill_1
XFILLER_21_750 VPWR VGND sg13g2_decap_4
XFILLER_21_783 VPWR VGND sg13g2_decap_8
XFILLER_5_905 VPWR VGND sg13g2_decap_8
XFILLER_4_426 VPWR VGND sg13g2_decap_8
XFILLER_0_610 VPWR VGND sg13g2_decap_8
XFILLER_0_687 VPWR VGND sg13g2_decap_8
XFILLER_16_511 VPWR VGND sg13g2_decap_8
XFILLER_28_371 VPWR VGND sg13g2_fill_2
XFILLER_28_393 VPWR VGND sg13g2_decap_8
XFILLER_43_352 VPWR VGND sg13g2_fill_2
XFILLER_43_341 VPWR VGND sg13g2_decap_8
XFILLER_16_544 VPWR VGND sg13g2_decap_8
XFILLER_44_886 VPWR VGND sg13g2_decap_8
XFILLER_43_396 VPWR VGND sg13g2_decap_8
XFILLER_15_1003 VPWR VGND sg13g2_decap_8
XFILLER_8_732 VPWR VGND sg13g2_decap_8
XFILLER_12_772 VPWR VGND sg13g2_decap_8
XFILLER_11_260 VPWR VGND sg13g2_fill_2
X_1660_ _1340_ _1342_ net308 _1343_ VPWR VGND sg13g2_nand3_1
X_1591_ net333 _1273_ net346 _1275_ VPWR VGND sg13g2_nand3_1
XFILLER_4_993 VPWR VGND sg13g2_decap_8
X_2212_ net225 net303 _0660_ VPWR VGND sg13g2_nor2_1
X_2143_ _0544_ VPWR _0615_ VGND _0588_ _0612_ sg13g2_o21ai_1
XFILLER_39_647 VPWR VGND sg13g2_decap_8
XFILLER_38_135 VPWR VGND sg13g2_decap_8
XFILLER_26_308 VPWR VGND sg13g2_fill_1
X_2074_ _0512_ _0425_ _0514_ _0548_ VPWR VGND sg13g2_a21o_1
XFILLER_35_820 VPWR VGND sg13g2_fill_2
XFILLER_46_190 VPWR VGND sg13g2_decap_8
XFILLER_34_352 VPWR VGND sg13g2_decap_4
XFILLER_14_18 VPWR VGND sg13g2_fill_2
XFILLER_34_385 VPWR VGND sg13g2_decap_8
XFILLER_14_29 VPWR VGND sg13g2_decap_4
XFILLER_22_547 VPWR VGND sg13g2_fill_2
X_2976_ net115 VGND VPWR _0133_ falutop.i2c_inst.data_in\[5\] net397 sg13g2_dfrbpq_1
X_1927_ _0404_ VPWR _0405_ VGND net374 net278 sg13g2_o21ai_1
X_1858_ _0337_ _0263_ _0336_ VPWR VGND sg13g2_xnor2_1
X_1789_ _0269_ _0260_ _0267_ VPWR VGND sg13g2_xnor2_1
XFILLER_29_157 VPWR VGND sg13g2_decap_8
XFILLER_44_116 VPWR VGND sg13g2_fill_1
XFILLER_38_691 VPWR VGND sg13g2_decap_8
XFILLER_25_341 VPWR VGND sg13g2_fill_1
XFILLER_13_503 VPWR VGND sg13g2_decap_8
XFILLER_41_856 VPWR VGND sg13g2_decap_8
XFILLER_13_547 VPWR VGND sg13g2_fill_1
XFILLER_9_518 VPWR VGND sg13g2_decap_8
XFILLER_40_399 VPWR VGND sg13g2_decap_4
XFILLER_5_702 VPWR VGND sg13g2_decap_8
XFILLER_4_212 VPWR VGND sg13g2_fill_1
XFILLER_4_201 VPWR VGND sg13g2_fill_1
XFILLER_5_779 VPWR VGND sg13g2_decap_8
XFILLER_1_952 VPWR VGND sg13g2_decap_8
XFILLER_49_923 VPWR VGND sg13g2_decap_8
XFILLER_0_484 VPWR VGND sg13g2_decap_8
XFILLER_48_455 VPWR VGND sg13g2_fill_1
Xhold70 _0930_ VPWR VGND net244 sg13g2_dlygate4sd3_1
Xhold92 falutop.i2c_inst.result\[10\] VPWR VGND net266 sg13g2_dlygate4sd3_1
Xhold81 falutop.i2c_inst.result\[8\] VPWR VGND net255 sg13g2_dlygate4sd3_1
XFILLER_29_691 VPWR VGND sg13g2_fill_2
XFILLER_36_639 VPWR VGND sg13g2_decap_8
XFILLER_17_842 VPWR VGND sg13g2_decap_8
X_2830_ _1112_ _1167_ _1168_ VPWR VGND sg13g2_and2_1
XFILLER_31_322 VPWR VGND sg13g2_decap_4
XFILLER_32_845 VPWR VGND sg13g2_decap_8
X_2761_ net335 net372 net352 _1100_ VPWR VGND sg13g2_nand3_1
XFILLER_31_388 VPWR VGND sg13g2_decap_4
X_2692_ _1023_ _1031_ _1032_ VPWR VGND sg13g2_nor2_2
X_1712_ VPWR _0193_ _0192_ VGND sg13g2_inv_1
X_1643_ _1326_ net343 net333 VPWR VGND sg13g2_nand2_1
X_1574_ _1194_ _1134_ net215 _1259_ VPWR VGND sg13g2_a21o_1
XFILLER_4_790 VPWR VGND sg13g2_decap_8
X_2126_ _0597_ _0596_ _0599_ VPWR VGND sg13g2_xor2_1
XFILLER_26_116 VPWR VGND sg13g2_decap_8
XFILLER_26_127 VPWR VGND sg13g2_fill_1
X_2057_ VGND VPWR _0753_ net281 _0532_ _0531_ sg13g2_a21oi_1
XFILLER_22_300 VPWR VGND sg13g2_decap_8
XFILLER_25_39 VPWR VGND sg13g2_fill_1
X_2959_ net161 VGND VPWR _0116_ falutop.div_inst.b\[3\] clknet_4_1_0_clk sg13g2_dfrbpq_1
XFILLER_10_528 VPWR VGND sg13g2_fill_1
XFILLER_22_388 VPWR VGND sg13g2_decap_8
XFILLER_2_749 VPWR VGND sg13g2_decap_8
XFILLER_49_219 VPWR VGND sg13g2_decap_8
XFILLER_46_904 VPWR VGND sg13g2_decap_8
XFILLER_17_116 VPWR VGND sg13g2_fill_1
XFILLER_26_661 VPWR VGND sg13g2_fill_1
XFILLER_14_845 VPWR VGND sg13g2_decap_8
XFILLER_41_675 VPWR VGND sg13g2_decap_8
XFILLER_13_344 VPWR VGND sg13g2_fill_1
XFILLER_15_72 VPWR VGND sg13g2_decap_8
XFILLER_15_83 VPWR VGND sg13g2_fill_1
XFILLER_40_163 VPWR VGND sg13g2_decap_8
XFILLER_9_359 VPWR VGND sg13g2_decap_8
XFILLER_12_1017 VPWR VGND sg13g2_decap_8
XFILLER_12_1028 VPWR VGND sg13g2_fill_1
XFILLER_31_71 VPWR VGND sg13g2_decap_8
XFILLER_5_576 VPWR VGND sg13g2_decap_8
XFILLER_49_720 VPWR VGND sg13g2_decap_8
XFILLER_37_915 VPWR VGND sg13g2_decap_8
XFILLER_49_797 VPWR VGND sg13g2_decap_8
XFILLER_36_458 VPWR VGND sg13g2_decap_8
XFILLER_16_160 VPWR VGND sg13g2_decap_8
XFILLER_17_683 VPWR VGND sg13g2_fill_1
XFILLER_16_171 VPWR VGND sg13g2_fill_1
XFILLER_20_815 VPWR VGND sg13g2_decap_8
XFILLER_31_141 VPWR VGND sg13g2_fill_1
XFILLER_32_653 VPWR VGND sg13g2_decap_8
X_2813_ _1151_ net354 net333 net369 VPWR VGND sg13g2_and3_1
XFILLER_31_185 VPWR VGND sg13g2_decap_8
XFILLER_31_196 VPWR VGND sg13g2_decap_8
XFILLER_9_882 VPWR VGND sg13g2_decap_8
X_2744_ _1081_ VPWR _1083_ VGND _1005_ _1007_ sg13g2_o21ai_1
XFILLER_8_392 VPWR VGND sg13g2_decap_8
X_2675_ VGND VPWR _1015_ _1011_ _0956_ sg13g2_or2_1
X_1626_ _1310_ _1206_ _1308_ VPWR VGND sg13g2_xnor2_1
X_1557_ net330 net366 net353 _1242_ VPWR VGND sg13g2_nand3_1
Xfanout305 _0899_ net305 VPWR VGND sg13g2_buf_8
Xfanout327 _0370_ net327 VPWR VGND sg13g2_buf_8
Xfanout338 net433 net338 VPWR VGND sg13g2_buf_8
Xfanout316 net317 net316 VPWR VGND sg13g2_buf_8
Xfanout349 net350 net349 VPWR VGND sg13g2_buf_8
XFILLER_28_937 VPWR VGND sg13g2_decap_8
X_2109_ _0565_ _0570_ _0582_ VPWR VGND sg13g2_nor2_1
XFILLER_39_296 VPWR VGND sg13g2_decap_8
XFILLER_36_38 VPWR VGND sg13g2_decap_8
XFILLER_14_108 VPWR VGND sg13g2_fill_1
XFILLER_42_439 VPWR VGND sg13g2_decap_4
XFILLER_23_642 VPWR VGND sg13g2_decap_8
XFILLER_35_480 VPWR VGND sg13g2_decap_8
XFILLER_10_325 VPWR VGND sg13g2_decap_8
XFILLER_11_848 VPWR VGND sg13g2_decap_8
XFILLER_10_347 VPWR VGND sg13g2_decap_8
XFILLER_10_336 VPWR VGND sg13g2_fill_1
XFILLER_6_307 VPWR VGND sg13g2_decap_8
XFILLER_2_546 VPWR VGND sg13g2_decap_8
X_2869__62 VPWR VGND net62 sg13g2_tiehi
XFILLER_46_701 VPWR VGND sg13g2_decap_8
XFILLER_19_926 VPWR VGND sg13g2_decap_8
XFILLER_46_778 VPWR VGND sg13g2_decap_8
XFILLER_45_233 VPWR VGND sg13g2_decap_8
XFILLER_18_458 VPWR VGND sg13g2_fill_1
XFILLER_33_406 VPWR VGND sg13g2_decap_8
XFILLER_34_929 VPWR VGND sg13g2_decap_8
XFILLER_14_620 VPWR VGND sg13g2_decap_8
XFILLER_42_984 VPWR VGND sg13g2_decap_8
XFILLER_41_483 VPWR VGND sg13g2_decap_8
XFILLER_9_123 VPWR VGND sg13g2_decap_8
XFILLER_14_686 VPWR VGND sg13g2_decap_8
XFILLER_14_697 VPWR VGND sg13g2_fill_2
XFILLER_13_196 VPWR VGND sg13g2_decap_8
XFILLER_42_81 VPWR VGND sg13g2_fill_2
X_2460_ _0764_ net2 _0859_ VPWR VGND sg13g2_nor2_1
XFILLER_6_874 VPWR VGND sg13g2_decap_8
X_2391_ falutop.div_inst.acc\[7\] falutop.div_inst.b1\[7\] _0802_ VPWR VGND sg13g2_xor2_1
XFILLER_3_75 VPWR VGND sg13g2_fill_1
XFILLER_49_583 VPWR VGND sg13g2_decap_8
XFILLER_3_1026 VPWR VGND sg13g2_fill_2
XFILLER_37_767 VPWR VGND sg13g2_decap_4
XFILLER_17_491 VPWR VGND sg13g2_fill_1
XFILLER_32_450 VPWR VGND sg13g2_decap_8
XFILLER_20_623 VPWR VGND sg13g2_decap_8
XFILLER_33_995 VPWR VGND sg13g2_decap_8
X_2727_ _1067_ _1065_ _1066_ _1063_ net326 VPWR VGND sg13g2_a22oi_1
X_2658_ net352 net375 _0998_ VPWR VGND sg13g2_nor2_2
X_2589_ net400 VPWR _0939_ VGND net226 net310 sg13g2_o21ai_1
X_1609_ VGND VPWR _0961_ _1127_ _1293_ _1292_ sg13g2_a21oi_1
XFILLER_41_1010 VPWR VGND sg13g2_decap_8
XFILLER_28_756 VPWR VGND sg13g2_fill_1
XFILLER_43_715 VPWR VGND sg13g2_decap_8
XFILLER_16_918 VPWR VGND sg13g2_decap_8
XFILLER_24_940 VPWR VGND sg13g2_decap_8
XFILLER_23_472 VPWR VGND sg13g2_decap_8
XFILLER_23_483 VPWR VGND sg13g2_fill_1
XFILLER_10_111 VPWR VGND sg13g2_decap_8
XFILLER_11_645 VPWR VGND sg13g2_decap_8
XFILLER_3_844 VPWR VGND sg13g2_decap_8
XFILLER_46_531 VPWR VGND sg13g2_decap_8
XFILLER_19_756 VPWR VGND sg13g2_decap_8
XFILLER_37_70 VPWR VGND sg13g2_decap_8
X_2910__158 VPWR VGND net158 sg13g2_tiehi
XFILLER_34_704 VPWR VGND sg13g2_fill_2
XFILLER_34_726 VPWR VGND sg13g2_decap_8
XFILLER_15_940 VPWR VGND sg13g2_decap_8
XFILLER_33_214 VPWR VGND sg13g2_decap_4
X_1960_ _0437_ _0417_ _0436_ VPWR VGND sg13g2_xnor2_1
XFILLER_30_965 VPWR VGND sg13g2_decap_8
X_1891_ _0336_ _0262_ _0334_ _0369_ VPWR VGND sg13g2_a21o_2
XFILLER_6_671 VPWR VGND sg13g2_decap_8
X_2512_ falutop.i2c_inst.data_in\[1\] falutop.data_in\[1\] net320 _0029_ VPWR VGND
+ sg13g2_mux2_1
XFILLER_5_192 VPWR VGND sg13g2_decap_8
X_2443_ _0848_ _0819_ _0820_ VPWR VGND sg13g2_xnor2_1
X_2374_ _0735_ net385 _0789_ VPWR VGND sg13g2_nor2_1
XFILLER_29_509 VPWR VGND sg13g2_decap_4
XFILLER_37_520 VPWR VGND sg13g2_decap_8
XFILLER_17_18 VPWR VGND sg13g2_decap_8
XFILLER_25_715 VPWR VGND sg13g2_fill_2
XFILLER_40_729 VPWR VGND sg13g2_decap_8
XFILLER_21_932 VPWR VGND sg13g2_decap_8
XFILLER_33_781 VPWR VGND sg13g2_decap_8
XFILLER_20_442 VPWR VGND sg13g2_decap_8
XFILLER_32_1009 VPWR VGND sg13g2_decap_8
XFILLER_4_608 VPWR VGND sg13g2_decap_8
XFILLER_0_869 VPWR VGND sg13g2_decap_8
XFILLER_48_829 VPWR VGND sg13g2_decap_8
XFILLER_47_339 VPWR VGND sg13g2_decap_8
XFILLER_43_501 VPWR VGND sg13g2_decap_8
XFILLER_28_575 VPWR VGND sg13g2_decap_8
XFILLER_43_523 VPWR VGND sg13g2_decap_8
XFILLER_43_512 VPWR VGND sg13g2_fill_1
XFILLER_8_914 VPWR VGND sg13g2_decap_8
XFILLER_12_954 VPWR VGND sg13g2_decap_8
XFILLER_23_280 VPWR VGND sg13g2_fill_2
XFILLER_7_424 VPWR VGND sg13g2_fill_1
XFILLER_7_413 VPWR VGND sg13g2_fill_2
XFILLER_7_457 VPWR VGND sg13g2_decap_8
XFILLER_3_641 VPWR VGND sg13g2_decap_8
XFILLER_2_195 VPWR VGND sg13g2_decap_8
XFILLER_47_840 VPWR VGND sg13g2_decap_8
X_2090_ _0524_ VPWR _0564_ VGND _0502_ _0522_ sg13g2_o21ai_1
XFILLER_19_531 VPWR VGND sg13g2_decap_8
XFILLER_46_350 VPWR VGND sg13g2_decap_4
XFILLER_0_21 VPWR VGND sg13g2_decap_8
XFILLER_19_575 VPWR VGND sg13g2_decap_8
XFILLER_19_586 VPWR VGND sg13g2_fill_1
XFILLER_0_98 VPWR VGND sg13g2_decap_8
XFILLER_22_707 VPWR VGND sg13g2_decap_8
XFILLER_22_718 VPWR VGND sg13g2_fill_2
X_2853__90 VPWR VGND net90 sg13g2_tiehi
X_1943_ _0420_ _0952_ _0419_ VPWR VGND sg13g2_xnor2_1
XFILLER_9_63 VPWR VGND sg13g2_decap_8
X_1874_ _0353_ _0322_ _0352_ VPWR VGND sg13g2_xnor2_1
X_2426_ _0831_ VPWR _0010_ VGND _0768_ _0834_ sg13g2_o21ai_1
X_2357_ _0776_ _0768_ _0774_ VPWR VGND sg13g2_nand2_2
XFILLER_28_39 VPWR VGND sg13g2_decap_8
X_2288_ net401 VPWR _0715_ VGND falutop.i2c_inst.data_in\[11\] _0714_ sg13g2_o21ai_1
XFILLER_44_309 VPWR VGND sg13g2_decap_8
XFILLER_25_523 VPWR VGND sg13g2_decap_8
XFILLER_44_27 VPWR VGND sg13g2_decap_8
XFILLER_25_556 VPWR VGND sg13g2_decap_8
XFILLER_12_239 VPWR VGND sg13g2_fill_1
XFILLER_21_740 VPWR VGND sg13g2_decap_4
XFILLER_21_762 VPWR VGND sg13g2_decap_8
XFILLER_4_405 VPWR VGND sg13g2_decap_8
XFILLER_20_294 VPWR VGND sg13g2_decap_8
XFILLER_0_666 VPWR VGND sg13g2_decap_8
XFILLER_48_637 VPWR VGND sg13g2_decap_8
XFILLER_29_840 VPWR VGND sg13g2_decap_4
XFILLER_47_147 VPWR VGND sg13g2_decap_4
XFILLER_29_895 VPWR VGND sg13g2_decap_8
XFILLER_44_865 VPWR VGND sg13g2_decap_8
XFILLER_43_375 VPWR VGND sg13g2_decap_8
XFILLER_16_578 VPWR VGND sg13g2_decap_8
X_2909__160 VPWR VGND net160 sg13g2_tiehi
XFILLER_31_559 VPWR VGND sg13g2_decap_8
X_2979__103 VPWR VGND net103 sg13g2_tiehi
XFILLER_8_711 VPWR VGND sg13g2_decap_8
XFILLER_12_751 VPWR VGND sg13g2_decap_8
XFILLER_34_93 VPWR VGND sg13g2_decap_8
XFILLER_7_221 VPWR VGND sg13g2_fill_2
XFILLER_8_788 VPWR VGND sg13g2_decap_8
X_1590_ _1274_ net346 net333 VPWR VGND sg13g2_nand2_1
XFILLER_4_972 VPWR VGND sg13g2_decap_8
XFILLER_39_626 VPWR VGND sg13g2_decap_8
XFILLER_39_615 VPWR VGND sg13g2_fill_2
X_2211_ VGND VPWR net303 _0659_ _0117_ _0657_ sg13g2_a21oi_1
XFILLER_22_4 VPWR VGND sg13g2_decap_4
X_2142_ _0593_ _0595_ _0614_ VPWR VGND sg13g2_nor2_1
XFILLER_22_1019 VPWR VGND sg13g2_decap_8
X_2986__129 VPWR VGND net129 sg13g2_tiehi
X_2073_ _0516_ VPWR _0547_ VGND _0510_ _0517_ sg13g2_o21ai_1
X_2975_ net119 VGND VPWR _0132_ falutop.i2c_inst.data_in\[4\] net397 sg13g2_dfrbpq_1
X_1926_ VGND VPWR _0749_ net278 _0404_ net285 sg13g2_a21oi_1
X_1857_ _0334_ _0335_ _0336_ VPWR VGND sg13g2_nor2_1
X_1788_ _0268_ _0260_ _0267_ VPWR VGND sg13g2_nand2_1
X_2409_ _0820_ falutop.div_inst.b1\[6\] falutop.div_inst.acc\[6\] VPWR VGND sg13g2_xnor2_1
XFILLER_29_136 VPWR VGND sg13g2_decap_8
XFILLER_45_618 VPWR VGND sg13g2_fill_1
XFILLER_45_607 VPWR VGND sg13g2_decap_4
XFILLER_25_331 VPWR VGND sg13g2_fill_1
XFILLER_26_854 VPWR VGND sg13g2_decap_8
XFILLER_26_865 VPWR VGND sg13g2_fill_2
XFILLER_25_386 VPWR VGND sg13g2_decap_8
XFILLER_5_758 VPWR VGND sg13g2_decap_8
XFILLER_1_931 VPWR VGND sg13g2_decap_8
XFILLER_49_902 VPWR VGND sg13g2_decap_8
XFILLER_0_463 VPWR VGND sg13g2_decap_8
XFILLER_49_979 VPWR VGND sg13g2_decap_8
Xhold60 falutop.div_inst.b\[3\] VPWR VGND net234 sg13g2_dlygate4sd3_1
Xhold71 falutop.div_inst.b1\[6\] VPWR VGND net245 sg13g2_dlygate4sd3_1
XFILLER_29_93 VPWR VGND sg13g2_decap_8
Xhold82 _0087_ VPWR VGND net256 sg13g2_dlygate4sd3_1
XFILLER_17_821 VPWR VGND sg13g2_decap_8
Xhold93 _0089_ VPWR VGND net267 sg13g2_dlygate4sd3_1
XFILLER_29_670 VPWR VGND sg13g2_fill_2
XFILLER_44_651 VPWR VGND sg13g2_decap_8
XFILLER_17_898 VPWR VGND sg13g2_decap_8
XFILLER_31_301 VPWR VGND sg13g2_decap_8
XFILLER_43_194 VPWR VGND sg13g2_decap_8
XFILLER_31_367 VPWR VGND sg13g2_decap_8
Xclkbuf_4_14_0_clk clknet_0_clk clknet_4_14_0_clk VPWR VGND sg13g2_buf_8
X_2760_ _1099_ net351 net339 VPWR VGND sg13g2_nand2_1
X_1711_ VGND VPWR _1304_ _0147_ _0192_ _0149_ sg13g2_a21oi_1
X_2691_ _1031_ net377 _1030_ VPWR VGND sg13g2_nand2_2
XFILLER_8_585 VPWR VGND sg13g2_decap_8
X_1642_ net407 VPWR _1325_ VGND net270 net305 sg13g2_o21ai_1
XFILLER_6_53 VPWR VGND sg13g2_decap_8
X_1573_ _1227_ _1235_ _1199_ _1258_ VPWR VGND _1257_ sg13g2_nand4_1
XFILLER_39_467 VPWR VGND sg13g2_fill_2
XFILLER_48_990 VPWR VGND sg13g2_decap_8
X_2125_ _0596_ _0597_ _0598_ VPWR VGND sg13g2_and2_1
XFILLER_19_180 VPWR VGND sg13g2_fill_2
XFILLER_25_18 VPWR VGND sg13g2_decap_8
XFILLER_26_139 VPWR VGND sg13g2_decap_8
X_2056_ _0994_ VPWR _0531_ VGND net365 net280 sg13g2_o21ai_1
XFILLER_41_109 VPWR VGND sg13g2_decap_4
XFILLER_35_662 VPWR VGND sg13g2_decap_8
XFILLER_22_312 VPWR VGND sg13g2_fill_1
XFILLER_23_846 VPWR VGND sg13g2_decap_8
XFILLER_22_356 VPWR VGND sg13g2_decap_4
X_2958_ net163 VGND VPWR _0115_ falutop.div_inst.b\[2\] clknet_4_0_0_clk sg13g2_dfrbpq_1
X_1909_ _0387_ _0380_ _0385_ VPWR VGND sg13g2_xnor2_1
X_2889_ net39 VGND VPWR _0046_ falutop.div_inst.done clknet_4_6_0_clk sg13g2_dfrbpq_2
XFILLER_9_8 VPWR VGND sg13g2_fill_2
XFILLER_2_728 VPWR VGND sg13g2_decap_8
XFILLER_1_238 VPWR VGND sg13g2_decap_4
X_2896__30 VPWR VGND net30 sg13g2_tiehi
XFILLER_14_824 VPWR VGND sg13g2_decap_8
XFILLER_25_150 VPWR VGND sg13g2_decap_4
XFILLER_13_312 VPWR VGND sg13g2_fill_2
XFILLER_40_142 VPWR VGND sg13g2_decap_8
XFILLER_9_305 VPWR VGND sg13g2_fill_2
XFILLER_13_356 VPWR VGND sg13g2_fill_1
XFILLER_9_338 VPWR VGND sg13g2_decap_8
XFILLER_31_50 VPWR VGND sg13g2_decap_8
XFILLER_5_555 VPWR VGND sg13g2_decap_8
Xoutput4 net4 uo_out[0] VPWR VGND sg13g2_buf_1
XFILLER_49_776 VPWR VGND sg13g2_decap_8
XFILLER_17_640 VPWR VGND sg13g2_fill_1
XFILLER_45_982 VPWR VGND sg13g2_decap_8
XFILLER_44_481 VPWR VGND sg13g2_decap_8
XFILLER_16_183 VPWR VGND sg13g2_decap_8
XFILLER_32_610 VPWR VGND sg13g2_fill_2
XFILLER_31_120 VPWR VGND sg13g2_decap_8
X_2812_ _1150_ net354 net369 VPWR VGND sg13g2_nand2_1
XFILLER_32_698 VPWR VGND sg13g2_decap_4
XFILLER_9_861 VPWR VGND sg13g2_decap_8
X_2743_ _1005_ _1007_ _1081_ _1082_ VPWR VGND sg13g2_nor3_1
X_2920__138 VPWR VGND net138 sg13g2_tiehi
X_2674_ _1012_ _1013_ _1014_ VPWR VGND sg13g2_nor2_2
X_1625_ _1206_ _1308_ _1309_ VPWR VGND sg13g2_nor2b_1
X_1556_ _1241_ net353 net330 net366 VPWR VGND sg13g2_and3_1
XFILLER_28_1014 VPWR VGND sg13g2_decap_8
Xfanout317 _0896_ net317 VPWR VGND sg13g2_buf_8
Xfanout328 net331 net328 VPWR VGND sg13g2_buf_8
Xfanout339 net342 net339 VPWR VGND sg13g2_buf_8
Xfanout306 _0899_ net306 VPWR VGND sg13g2_buf_2
X_2878__52 VPWR VGND net52 sg13g2_tiehi
XFILLER_28_916 VPWR VGND sg13g2_decap_8
XFILLER_27_415 VPWR VGND sg13g2_decap_8
XFILLER_27_426 VPWR VGND sg13g2_fill_2
XFILLER_27_448 VPWR VGND sg13g2_decap_4
X_2108_ VGND VPWR _0576_ _0580_ _0092_ _0581_ sg13g2_a21oi_1
X_2039_ _0246_ _0513_ _0514_ VPWR VGND sg13g2_nor2b_1
XFILLER_36_993 VPWR VGND sg13g2_decap_8
XFILLER_23_621 VPWR VGND sg13g2_decap_8
XFILLER_23_665 VPWR VGND sg13g2_fill_1
XFILLER_35_1018 VPWR VGND sg13g2_decap_8
XFILLER_11_827 VPWR VGND sg13g2_decap_8
XFILLER_23_687 VPWR VGND sg13g2_decap_8
XFILLER_22_186 VPWR VGND sg13g2_fill_1
X_2948__67 VPWR VGND net67 sg13g2_tiehi
XFILLER_2_525 VPWR VGND sg13g2_decap_8
XFILLER_19_905 VPWR VGND sg13g2_decap_8
XFILLER_18_415 VPWR VGND sg13g2_decap_8
XFILLER_46_757 VPWR VGND sg13g2_decap_8
XFILLER_18_437 VPWR VGND sg13g2_fill_2
XFILLER_34_908 VPWR VGND sg13g2_decap_8
XFILLER_26_470 VPWR VGND sg13g2_decap_8
XFILLER_26_481 VPWR VGND sg13g2_fill_2
XFILLER_42_963 VPWR VGND sg13g2_decap_8
XFILLER_41_451 VPWR VGND sg13g2_fill_2
XFILLER_13_175 VPWR VGND sg13g2_decap_8
XFILLER_9_146 VPWR VGND sg13g2_fill_1
XFILLER_6_853 VPWR VGND sg13g2_decap_8
XFILLER_5_352 VPWR VGND sg13g2_decap_4
XFILLER_5_385 VPWR VGND sg13g2_fill_2
X_2390_ _0801_ net209 net289 VPWR VGND sg13g2_nand2_1
XFILLER_3_54 VPWR VGND sg13g2_decap_8
XFILLER_3_32 VPWR VGND sg13g2_decap_8
XFILLER_3_87 VPWR VGND sg13g2_decap_4
XFILLER_49_562 VPWR VGND sg13g2_decap_8
X_2875__55 VPWR VGND net55 sg13g2_tiehi
XFILLER_37_724 VPWR VGND sg13g2_fill_2
XFILLER_3_1005 VPWR VGND sg13g2_decap_8
XFILLER_37_735 VPWR VGND sg13g2_decap_8
XFILLER_18_982 VPWR VGND sg13g2_decap_8
XFILLER_33_974 VPWR VGND sg13g2_decap_8
X_2726_ net339 _1064_ _1066_ VPWR VGND sg13g2_nor2_1
X_2657_ _0996_ VPWR _0997_ VGND net352 net279 sg13g2_o21ai_1
X_1608_ VGND VPWR _1052_ _1291_ _1292_ _0961_ sg13g2_a21oi_1
X_2588_ VGND VPWR _0735_ net309 _0068_ _0938_ sg13g2_a21oi_1
X_1539_ VGND VPWR _0965_ _1119_ _1224_ _1221_ sg13g2_a21oi_1
XFILLER_27_267 VPWR VGND sg13g2_fill_1
XFILLER_42_237 VPWR VGND sg13g2_decap_8
XFILLER_42_204 VPWR VGND sg13g2_decap_8
XFILLER_27_289 VPWR VGND sg13g2_fill_1
XFILLER_42_248 VPWR VGND sg13g2_fill_2
XFILLER_11_624 VPWR VGND sg13g2_decap_8
XFILLER_24_996 VPWR VGND sg13g2_decap_8
XFILLER_7_639 VPWR VGND sg13g2_decap_8
XFILLER_3_823 VPWR VGND sg13g2_decap_8
XFILLER_2_399 VPWR VGND sg13g2_decap_8
XFILLER_18_201 VPWR VGND sg13g2_decap_4
XFILLER_46_587 VPWR VGND sg13g2_decap_4
X_2872__58 VPWR VGND net58 sg13g2_tiehi
XFILLER_33_237 VPWR VGND sg13g2_fill_1
XFILLER_15_996 VPWR VGND sg13g2_decap_8
XFILLER_18_1024 VPWR VGND sg13g2_decap_4
XFILLER_41_292 VPWR VGND sg13g2_fill_2
XFILLER_14_484 VPWR VGND sg13g2_fill_2
XFILLER_30_944 VPWR VGND sg13g2_decap_8
X_1890_ _0348_ VPWR _0368_ VGND _0332_ _0349_ sg13g2_o21ai_1
XFILLER_6_650 VPWR VGND sg13g2_decap_8
X_2511_ falutop.i2c_inst.data_in\[0\] falutop.data_in\[0\] net319 _0028_ VPWR VGND
+ sg13g2_mux2_1
XFILLER_5_171 VPWR VGND sg13g2_decap_8
X_2442_ _0847_ net186 net289 VPWR VGND sg13g2_nand2_1
X_2919__140 VPWR VGND net140 sg13g2_tiehi
X_2373_ VGND VPWR net288 _0787_ _0003_ _0788_ sg13g2_a21oi_1
X_2989__105 VPWR VGND net105 sg13g2_tiehi
XFILLER_21_911 VPWR VGND sg13g2_decap_8
XFILLER_20_476 VPWR VGND sg13g2_decap_8
XFILLER_21_988 VPWR VGND sg13g2_decap_8
X_2709_ _1049_ net379 falutop.alu_inst.op\[1\] VPWR VGND sg13g2_nand2b_1
X_2972__131 VPWR VGND net131 sg13g2_tiehi
XFILLER_0_848 VPWR VGND sg13g2_decap_8
XFILLER_48_808 VPWR VGND sg13g2_decap_8
XFILLER_28_554 VPWR VGND sg13g2_decap_8
XFILLER_16_727 VPWR VGND sg13g2_decap_8
XFILLER_16_749 VPWR VGND sg13g2_decap_8
XFILLER_12_933 VPWR VGND sg13g2_decap_8
XFILLER_11_443 VPWR VGND sg13g2_decap_8
XFILLER_7_436 VPWR VGND sg13g2_decap_4
XFILLER_23_84 VPWR VGND sg13g2_fill_1
XFILLER_3_620 VPWR VGND sg13g2_decap_8
XFILLER_3_697 VPWR VGND sg13g2_decap_8
XFILLER_2_174 VPWR VGND sg13g2_decap_8
XFILLER_48_92 VPWR VGND sg13g2_fill_1
XFILLER_47_896 VPWR VGND sg13g2_decap_8
XFILLER_46_373 VPWR VGND sg13g2_fill_2
XFILLER_0_77 VPWR VGND sg13g2_decap_8
XFILLER_46_395 VPWR VGND sg13g2_decap_8
XFILLER_15_760 VPWR VGND sg13g2_decap_8
XFILLER_21_207 VPWR VGND sg13g2_decap_8
XFILLER_9_42 VPWR VGND sg13g2_decap_8
XFILLER_14_270 VPWR VGND sg13g2_decap_8
XFILLER_15_793 VPWR VGND sg13g2_decap_8
X_1942_ _0419_ net332 net364 VPWR VGND sg13g2_nand2_1
X_1873_ _0352_ _0323_ _0350_ VPWR VGND sg13g2_xnor2_1
XFILLER_30_796 VPWR VGND sg13g2_decap_8
XFILLER_43_0 VPWR VGND sg13g2_decap_8
X_2425_ _0833_ VPWR _0834_ VGND net213 net282 sg13g2_o21ai_1
XFILLER_9_1022 VPWR VGND sg13g2_decap_8
X_2356_ _0767_ _0773_ _0775_ VPWR VGND sg13g2_nor2_1
XFILLER_28_18 VPWR VGND sg13g2_decap_8
XFILLER_38_841 VPWR VGND sg13g2_decap_8
X_2287_ _0685_ _0707_ _0714_ VPWR VGND sg13g2_nor2_1
XFILLER_37_362 VPWR VGND sg13g2_decap_8
XFILLER_25_502 VPWR VGND sg13g2_decap_8
XFILLER_37_395 VPWR VGND sg13g2_decap_8
XFILLER_40_527 VPWR VGND sg13g2_decap_8
XFILLER_20_251 VPWR VGND sg13g2_decap_8
XFILLER_20_273 VPWR VGND sg13g2_decap_8
XFILLER_0_645 VPWR VGND sg13g2_decap_8
XFILLER_47_126 VPWR VGND sg13g2_decap_8
XFILLER_47_159 VPWR VGND sg13g2_fill_2
XFILLER_29_852 VPWR VGND sg13g2_decap_8
XFILLER_43_310 VPWR VGND sg13g2_fill_2
XFILLER_28_373 VPWR VGND sg13g2_fill_1
XFILLER_44_844 VPWR VGND sg13g2_decap_8
XFILLER_12_730 VPWR VGND sg13g2_decap_8
XFILLER_34_72 VPWR VGND sg13g2_decap_8
XFILLER_11_240 VPWR VGND sg13g2_decap_8
XFILLER_11_284 VPWR VGND sg13g2_decap_8
XFILLER_8_767 VPWR VGND sg13g2_decap_8
XFILLER_7_288 VPWR VGND sg13g2_decap_8
XFILLER_4_951 VPWR VGND sg13g2_decap_8
XFILLER_3_494 VPWR VGND sg13g2_decap_8
X_2210_ _0659_ falutop.data_in\[4\] _0658_ VPWR VGND sg13g2_xnor2_1
X_2141_ _0544_ _0588_ _0612_ _0613_ VPWR VGND sg13g2_nor3_1
XFILLER_15_4 VPWR VGND sg13g2_fill_2
X_2072_ VPWR _0546_ _0545_ VGND sg13g2_inv_1
XFILLER_47_693 VPWR VGND sg13g2_decap_8
XFILLER_47_660 VPWR VGND sg13g2_decap_8
XFILLER_34_310 VPWR VGND sg13g2_fill_2
XFILLER_35_866 VPWR VGND sg13g2_decap_4
XFILLER_35_899 VPWR VGND sg13g2_decap_8
XFILLER_22_527 VPWR VGND sg13g2_decap_8
XFILLER_22_549 VPWR VGND sg13g2_fill_1
X_2974_ net123 VGND VPWR _0131_ falutop.i2c_inst.data_in\[3\] net395 sg13g2_dfrbpq_1
X_1925_ _0400_ _0402_ _0403_ VPWR VGND sg13g2_nor2b_2
XFILLER_30_582 VPWR VGND sg13g2_fill_2
X_1856_ _0335_ net361 net344 net364 net341 VPWR VGND sg13g2_a22oi_1
X_1787_ _0266_ _0196_ _0267_ VPWR VGND sg13g2_xor2_1
X_2408_ _0818_ _0817_ _0804_ _0819_ VPWR VGND sg13g2_a21o_1
X_2339_ net276 _0758_ VPWR VGND sg13g2_inv_4
XFILLER_29_115 VPWR VGND sg13g2_decap_8
X_2930__118 VPWR VGND net118 sg13g2_tiehi
XFILLER_40_302 VPWR VGND sg13g2_decap_8
XFILLER_38_1027 VPWR VGND sg13g2_fill_2
XFILLER_38_1016 VPWR VGND sg13g2_decap_8
XFILLER_25_365 VPWR VGND sg13g2_decap_8
XFILLER_13_538 VPWR VGND sg13g2_decap_8
XFILLER_40_379 VPWR VGND sg13g2_decap_8
XFILLER_21_571 VPWR VGND sg13g2_fill_1
XFILLER_5_737 VPWR VGND sg13g2_decap_8
XFILLER_4_247 VPWR VGND sg13g2_decap_4
XFILLER_1_910 VPWR VGND sg13g2_decap_8
XFILLER_0_442 VPWR VGND sg13g2_decap_8
XFILLER_1_987 VPWR VGND sg13g2_decap_8
XFILLER_49_958 VPWR VGND sg13g2_decap_8
Xhold50 falutop.div_inst.val\[2\] VPWR VGND net224 sg13g2_dlygate4sd3_1
Xhold72 falutop.div_inst.b1\[3\] VPWR VGND net246 sg13g2_dlygate4sd3_1
Xhold61 falutop.div_inst.acc\[0\] VPWR VGND net235 sg13g2_dlygate4sd3_1
Xhold83 falutop.i2c_inst.result\[9\] VPWR VGND net257 sg13g2_dlygate4sd3_1
Xhold94 falutop.i2c_inst.result\[2\] VPWR VGND net268 sg13g2_dlygate4sd3_1
XFILLER_28_192 VPWR VGND sg13g2_decap_8
XFILLER_44_685 VPWR VGND sg13g2_decap_8
XFILLER_16_365 VPWR VGND sg13g2_fill_1
XFILLER_16_376 VPWR VGND sg13g2_fill_2
XFILLER_17_877 VPWR VGND sg13g2_decap_8
XFILLER_43_184 VPWR VGND sg13g2_decap_4
XFILLER_31_346 VPWR VGND sg13g2_decap_8
XFILLER_40_891 VPWR VGND sg13g2_decap_8
XFILLER_12_582 VPWR VGND sg13g2_decap_8
XFILLER_8_564 VPWR VGND sg13g2_decap_8
XFILLER_12_593 VPWR VGND sg13g2_fill_1
X_1710_ _0163_ _1344_ _0166_ _0191_ VPWR VGND sg13g2_a21o_1
X_2690_ net378 _1013_ _1030_ VPWR VGND sg13g2_nor2_1
XFILLER_6_32 VPWR VGND sg13g2_decap_8
X_1641_ _0083_ net400 _1319_ net426 VPWR VGND sg13g2_and3_1
X_1572_ _1257_ _1256_ net308 _1144_ _1014_ VPWR VGND sg13g2_a22oi_1
XFILLER_39_413 VPWR VGND sg13g2_decap_4
XFILLER_6_1014 VPWR VGND sg13g2_decap_8
X_2124_ _0562_ VPWR _0597_ VGND _0541_ _0560_ sg13g2_o21ai_1
XFILLER_39_479 VPWR VGND sg13g2_decap_8
XFILLER_27_619 VPWR VGND sg13g2_decap_8
XFILLER_47_490 VPWR VGND sg13g2_decap_8
X_2055_ _0528_ _0529_ _0530_ VPWR VGND sg13g2_nor2b_1
XFILLER_23_825 VPWR VGND sg13g2_decap_8
XFILLER_23_869 VPWR VGND sg13g2_decap_8
XFILLER_34_195 VPWR VGND sg13g2_decap_8
XFILLER_41_18 VPWR VGND sg13g2_decap_8
X_2957_ net165 VGND VPWR _0114_ falutop.div_inst.b\[1\] clknet_4_1_0_clk sg13g2_dfrbpq_1
X_1908_ _0380_ _0385_ _0386_ VPWR VGND sg13g2_nor2b_1
X_2888_ net41 VGND VPWR _0045_ falutop.div_inst.quo\[0\] clknet_4_2_0_clk sg13g2_dfrbpq_1
X_1839_ net407 VPWR _0319_ VGND net247 net304 sg13g2_o21ai_1
XFILLER_2_707 VPWR VGND sg13g2_decap_8
XFILLER_18_608 VPWR VGND sg13g2_decap_8
XFILLER_46_939 VPWR VGND sg13g2_decap_8
XFILLER_39_980 VPWR VGND sg13g2_decap_8
XFILLER_26_630 VPWR VGND sg13g2_decap_4
XFILLER_14_803 VPWR VGND sg13g2_decap_8
XFILLER_26_652 VPWR VGND sg13g2_decap_4
XFILLER_13_335 VPWR VGND sg13g2_decap_8
XFILLER_9_317 VPWR VGND sg13g2_decap_8
XFILLER_5_534 VPWR VGND sg13g2_decap_8
XFILLER_1_784 VPWR VGND sg13g2_decap_8
XFILLER_49_755 VPWR VGND sg13g2_decap_8
XFILLER_45_961 VPWR VGND sg13g2_decap_8
XFILLER_17_696 VPWR VGND sg13g2_decap_8
XFILLER_32_633 VPWR VGND sg13g2_decap_8
X_2811_ _1149_ net350 net337 VPWR VGND sg13g2_nand2_1
XFILLER_9_840 VPWR VGND sg13g2_decap_8
XFILLER_13_891 VPWR VGND sg13g2_decap_8
X_2742_ _1003_ _0961_ _1002_ _1081_ VPWR VGND sg13g2_a21o_1
X_2673_ _1013_ net380 falutop.alu_inst.op\[0\] VPWR VGND sg13g2_nand2_2
X_1624_ _1308_ _1303_ _1306_ VPWR VGND sg13g2_xnor2_1
X_1555_ _1240_ net349 net333 VPWR VGND sg13g2_nand2_1
Xfanout318 _1134_ net318 VPWR VGND sg13g2_buf_8
Xfanout307 _0898_ net307 VPWR VGND sg13g2_buf_8
Xfanout329 net330 net329 VPWR VGND sg13g2_buf_8
XFILLER_39_254 VPWR VGND sg13g2_decap_8
X_2107_ net409 VPWR _0581_ VGND net271 net306 sg13g2_o21ai_1
X_2038_ _0513_ _0426_ _0512_ VPWR VGND sg13g2_xnor2_1
XFILLER_36_972 VPWR VGND sg13g2_decap_8
X_2929__120 VPWR VGND net120 sg13g2_tiehi
XFILLER_11_806 VPWR VGND sg13g2_decap_8
XFILLER_22_176 VPWR VGND sg13g2_decap_4
XFILLER_2_504 VPWR VGND sg13g2_decap_8
Xclkbuf_4_13_0_clk clknet_0_clk clknet_4_13_0_clk VPWR VGND sg13g2_buf_8
XFILLER_46_736 VPWR VGND sg13g2_fill_1
XFILLER_45_224 VPWR VGND sg13g2_decap_4
XFILLER_18_449 VPWR VGND sg13g2_fill_2
XFILLER_27_994 VPWR VGND sg13g2_decap_8
XFILLER_42_942 VPWR VGND sg13g2_decap_8
XFILLER_41_430 VPWR VGND sg13g2_decap_8
XFILLER_13_121 VPWR VGND sg13g2_decap_4
XFILLER_6_832 VPWR VGND sg13g2_decap_8
XFILLER_5_331 VPWR VGND sg13g2_decap_8
XFILLER_10_883 VPWR VGND sg13g2_decap_8
XFILLER_47_7 VPWR VGND sg13g2_decap_8
XFILLER_5_375 VPWR VGND sg13g2_fill_1
XFILLER_3_11 VPWR VGND sg13g2_decap_8
XFILLER_49_541 VPWR VGND sg13g2_decap_8
XFILLER_1_581 VPWR VGND sg13g2_decap_8
XFILLER_3_1028 VPWR VGND sg13g2_fill_1
XFILLER_18_961 VPWR VGND sg13g2_decap_8
XFILLER_17_482 VPWR VGND sg13g2_decap_8
XFILLER_24_419 VPWR VGND sg13g2_decap_8
XFILLER_32_430 VPWR VGND sg13g2_decap_8
XFILLER_33_953 VPWR VGND sg13g2_decap_8
XFILLER_20_658 VPWR VGND sg13g2_decap_8
XFILLER_32_485 VPWR VGND sg13g2_decap_8
X_2725_ _0752_ VPWR _1065_ VGND net334 net323 sg13g2_o21ai_1
XFILLER_8_191 VPWR VGND sg13g2_decap_8
X_2656_ VGND VPWR _0759_ net279 _0996_ net285 sg13g2_a21oi_1
X_1607_ _1291_ net342 _0756_ VPWR VGND sg13g2_nand2_1
X_2587_ net400 VPWR _0938_ VGND net219 net310 sg13g2_o21ai_1
X_1538_ _0756_ _0966_ _1053_ _1223_ VPWR VGND sg13g2_nor3_1
XFILLER_47_28 VPWR VGND sg13g2_fill_2
XFILLER_28_703 VPWR VGND sg13g2_decap_8
XFILLER_28_747 VPWR VGND sg13g2_fill_1
XFILLER_27_279 VPWR VGND sg13g2_fill_1
XFILLER_36_791 VPWR VGND sg13g2_decap_4
XFILLER_23_430 VPWR VGND sg13g2_decap_8
XFILLER_24_975 VPWR VGND sg13g2_decap_8
XFILLER_10_168 VPWR VGND sg13g2_fill_1
XFILLER_10_157 VPWR VGND sg13g2_decap_8
XFILLER_10_135 VPWR VGND sg13g2_fill_2
XFILLER_7_618 VPWR VGND sg13g2_decap_8
XFILLER_6_106 VPWR VGND sg13g2_fill_1
XFILLER_12_20 VPWR VGND sg13g2_decap_8
XFILLER_10_179 VPWR VGND sg13g2_decap_4
XFILLER_3_802 VPWR VGND sg13g2_decap_8
XFILLER_12_64 VPWR VGND sg13g2_decap_4
XFILLER_3_879 VPWR VGND sg13g2_decap_8
XFILLER_2_378 VPWR VGND sg13g2_decap_8
XFILLER_19_714 VPWR VGND sg13g2_decap_4
XFILLER_46_522 VPWR VGND sg13g2_decap_4
XFILLER_19_736 VPWR VGND sg13g2_decap_8
XFILLER_46_566 VPWR VGND sg13g2_decap_8
XFILLER_18_235 VPWR VGND sg13g2_decap_8
XFILLER_34_706 VPWR VGND sg13g2_fill_1
XFILLER_18_1003 VPWR VGND sg13g2_decap_8
XFILLER_41_260 VPWR VGND sg13g2_decap_8
XFILLER_15_975 VPWR VGND sg13g2_decap_8
XFILLER_30_923 VPWR VGND sg13g2_decap_8
XFILLER_10_680 VPWR VGND sg13g2_decap_8
X_2510_ net195 net300 _0027_ VPWR VGND sg13g2_nor2_1
X_2441_ _0843_ VPWR _0013_ VGND _0768_ _0846_ sg13g2_o21ai_1
X_2372_ net182 net287 _0788_ VPWR VGND sg13g2_nor2_1
X_2950__63 VPWR VGND net63 sg13g2_tiehi
XFILLER_37_500 VPWR VGND sg13g2_decap_8
XFILLER_49_393 VPWR VGND sg13g2_decap_8
XFILLER_17_290 VPWR VGND sg13g2_fill_2
XFILLER_18_791 VPWR VGND sg13g2_decap_8
XFILLER_20_411 VPWR VGND sg13g2_decap_8
XFILLER_32_282 VPWR VGND sg13g2_decap_8
XFILLER_21_967 VPWR VGND sg13g2_decap_8
X_2708_ VGND VPWR _1044_ _1047_ _1048_ _0998_ sg13g2_a21oi_1
XFILLER_3_109 VPWR VGND sg13g2_decap_4
X_2639_ _0978_ _0967_ _0966_ _0979_ VPWR VGND sg13g2_a21o_2
XFILLER_0_827 VPWR VGND sg13g2_decap_8
X_2941__85 VPWR VGND net85 sg13g2_tiehi
XFILLER_16_706 VPWR VGND sg13g2_decap_8
XFILLER_15_249 VPWR VGND sg13g2_decap_8
XFILLER_12_912 VPWR VGND sg13g2_decap_8
XFILLER_23_30 VPWR VGND sg13g2_decap_8
XFILLER_23_282 VPWR VGND sg13g2_fill_1
XFILLER_24_794 VPWR VGND sg13g2_decap_8
XFILLER_12_989 VPWR VGND sg13g2_decap_8
XFILLER_23_41 VPWR VGND sg13g2_fill_2
XFILLER_23_52 VPWR VGND sg13g2_fill_1
XFILLER_8_949 VPWR VGND sg13g2_decap_8
XFILLER_23_96 VPWR VGND sg13g2_fill_1
XFILLER_48_1018 VPWR VGND sg13g2_decap_8
XFILLER_3_676 VPWR VGND sg13g2_decap_8
XFILLER_19_511 VPWR VGND sg13g2_decap_8
XFILLER_19_522 VPWR VGND sg13g2_fill_1
XFILLER_47_875 VPWR VGND sg13g2_decap_8
XFILLER_0_1009 VPWR VGND sg13g2_decap_8
XFILLER_0_56 VPWR VGND sg13g2_decap_8
XFILLER_19_599 VPWR VGND sg13g2_decap_8
XFILLER_34_514 VPWR VGND sg13g2_decap_8
XFILLER_9_21 VPWR VGND sg13g2_decap_8
XFILLER_34_569 VPWR VGND sg13g2_fill_2
X_1941_ VGND VPWR _0379_ _0387_ _0418_ _0386_ sg13g2_a21oi_1
XFILLER_30_775 VPWR VGND sg13g2_decap_8
X_1872_ _0323_ _0350_ _0351_ VPWR VGND sg13g2_nor2b_1
XFILLER_31_1011 VPWR VGND sg13g2_decap_8
XFILLER_7_982 VPWR VGND sg13g2_decap_8
X_2424_ _0833_ net282 _0832_ VPWR VGND sg13g2_nand2_1
XFILLER_9_1001 VPWR VGND sg13g2_decap_8
X_2355_ _0774_ net387 _0771_ VPWR VGND sg13g2_nand2_2
XFILLER_36_0 VPWR VGND sg13g2_fill_2
XFILLER_29_308 VPWR VGND sg13g2_fill_1
X_2286_ VGND VPWR net389 _0712_ _0138_ _0713_ sg13g2_a21oi_1
XFILLER_38_897 VPWR VGND sg13g2_decap_8
XFILLER_37_385 VPWR VGND sg13g2_fill_1
XFILLER_40_506 VPWR VGND sg13g2_decap_8
XFILLER_21_797 VPWR VGND sg13g2_fill_1
XFILLER_5_919 VPWR VGND sg13g2_decap_8
XFILLER_0_624 VPWR VGND sg13g2_decap_8
XFILLER_48_606 VPWR VGND sg13g2_fill_2
XFILLER_18_30 VPWR VGND sg13g2_fill_1
XFILLER_44_823 VPWR VGND sg13g2_decap_8
XFILLER_18_63 VPWR VGND sg13g2_decap_8
XFILLER_43_366 VPWR VGND sg13g2_decap_4
XFILLER_34_51 VPWR VGND sg13g2_decap_8
XFILLER_15_1017 VPWR VGND sg13g2_decap_8
XFILLER_15_1028 VPWR VGND sg13g2_fill_1
X_2850__95 VPWR VGND net95 sg13g2_tiehi
XFILLER_8_746 VPWR VGND sg13g2_decap_8
XFILLER_12_786 VPWR VGND sg13g2_decap_8
XFILLER_7_256 VPWR VGND sg13g2_fill_2
XFILLER_7_245 VPWR VGND sg13g2_fill_2
XFILLER_4_930 VPWR VGND sg13g2_decap_8
XFILLER_3_473 VPWR VGND sg13g2_decap_8
XFILLER_39_617 VPWR VGND sg13g2_fill_1
X_2140_ _0591_ _0545_ _0590_ _0612_ VPWR VGND sg13g2_a21o_1
XFILLER_38_116 VPWR VGND sg13g2_fill_2
X_2071_ _0542_ net327 _0545_ VPWR VGND sg13g2_xor2_1
XFILLER_38_149 VPWR VGND sg13g2_decap_8
XFILLER_19_330 VPWR VGND sg13g2_decap_8
XFILLER_35_845 VPWR VGND sg13g2_decap_8
XFILLER_22_506 VPWR VGND sg13g2_decap_8
XFILLER_15_580 VPWR VGND sg13g2_fill_1
XFILLER_34_399 VPWR VGND sg13g2_decap_8
X_2973_ net127 VGND VPWR _0130_ falutop.i2c_inst.data_in\[2\] net395 sg13g2_dfrbpq_1
X_1924_ VPWR VGND _0320_ net293 _0401_ _0354_ _0402_ _0398_ sg13g2_a221oi_1
XFILLER_30_561 VPWR VGND sg13g2_decap_8
X_1855_ net344 net340 net365 net361 _0334_ VPWR VGND sg13g2_and4_1
X_1786_ _0266_ _0263_ _0264_ VPWR VGND sg13g2_xnor2_1
X_2407_ _0818_ falutop.div_inst.b1\[5\] falutop.div_inst.acc\[5\] VPWR VGND sg13g2_xnor2_1
X_2338_ _0757_ net378 VPWR VGND sg13g2_inv_2
X_2269_ VGND VPWR net391 _0700_ _0133_ _0701_ sg13g2_a21oi_1
XFILLER_37_182 VPWR VGND sg13g2_decap_8
XFILLER_25_322 VPWR VGND sg13g2_decap_4
XFILLER_26_834 VPWR VGND sg13g2_decap_8
XFILLER_26_889 VPWR VGND sg13g2_decap_8
XFILLER_41_826 VPWR VGND sg13g2_fill_2
XFILLER_40_358 VPWR VGND sg13g2_decap_8
XFILLER_5_716 VPWR VGND sg13g2_decap_8
XFILLER_0_421 VPWR VGND sg13g2_decap_8
XFILLER_1_966 VPWR VGND sg13g2_decap_8
XFILLER_49_937 VPWR VGND sg13g2_decap_8
Xhold40 _0009_ VPWR VGND net214 sg13g2_dlygate4sd3_1
XFILLER_0_498 VPWR VGND sg13g2_decap_8
XFILLER_48_469 VPWR VGND sg13g2_decap_4
Xhold51 falutop.div_inst.b\[5\] VPWR VGND net225 sg13g2_dlygate4sd3_1
Xhold62 _0007_ VPWR VGND net236 sg13g2_dlygate4sd3_1
Xhold73 falutop.i2c_inst.result\[7\] VPWR VGND net247 sg13g2_dlygate4sd3_1
XFILLER_36_609 VPWR VGND sg13g2_decap_8
Xhold95 _0081_ VPWR VGND net269 sg13g2_dlygate4sd3_1
XFILLER_29_650 VPWR VGND sg13g2_decap_4
Xhold84 _0088_ VPWR VGND net258 sg13g2_dlygate4sd3_1
XFILLER_17_856 VPWR VGND sg13g2_decap_8
XFILLER_43_163 VPWR VGND sg13g2_decap_8
XFILLER_40_870 VPWR VGND sg13g2_decap_8
XFILLER_12_561 VPWR VGND sg13g2_fill_2
XFILLER_8_543 VPWR VGND sg13g2_decap_8
XFILLER_6_11 VPWR VGND sg13g2_decap_8
X_1640_ _1322_ _1323_ net316 _1324_ VPWR VGND sg13g2_nand3_1
X_1571_ _1255_ _1161_ _1256_ VPWR VGND sg13g2_xor2_1
XFILLER_6_77 VPWR VGND sg13g2_decap_8
XFILLER_3_281 VPWR VGND sg13g2_decap_8
X_2123_ _0594_ _0543_ _0596_ VPWR VGND sg13g2_xor2_1
X_2054_ _0527_ VPWR _0529_ VGND _0499_ _0500_ sg13g2_o21ai_1
XFILLER_19_182 VPWR VGND sg13g2_fill_1
XFILLER_35_642 VPWR VGND sg13g2_decap_8
XFILLER_34_130 VPWR VGND sg13g2_decap_8
XFILLER_22_325 VPWR VGND sg13g2_decap_8
XFILLER_22_336 VPWR VGND sg13g2_fill_2
X_2956_ net29 VGND VPWR _0113_ falutop.div_inst.b\[0\] clknet_4_1_0_clk sg13g2_dfrbpq_1
XFILLER_31_870 VPWR VGND sg13g2_fill_2
X_1907_ _0384_ _0209_ _0385_ VPWR VGND sg13g2_xor2_1
XFILLER_31_892 VPWR VGND sg13g2_decap_8
X_2887_ net43 VGND VPWR _0044_ falutop.i2c_inst.sda_o net395 sg13g2_dfrbpq_1
X_1838_ VGND VPWR _0316_ _0317_ _0318_ net307 sg13g2_a21oi_1
X_1769_ _0250_ _0247_ _1052_ _0246_ _1051_ VPWR VGND sg13g2_a22oi_1
XFILLER_46_918 VPWR VGND sg13g2_decap_8
Xheichips25_template_20 VPWR VGND uio_out[7] sg13g2_tielo
XFILLER_17_108 VPWR VGND sg13g2_fill_1
XFILLER_26_675 VPWR VGND sg13g2_decap_8
XFILLER_41_634 VPWR VGND sg13g2_decap_8
XFILLER_13_314 VPWR VGND sg13g2_fill_1
XFILLER_40_133 VPWR VGND sg13g2_fill_2
XFILLER_9_307 VPWR VGND sg13g2_fill_1
XFILLER_14_859 VPWR VGND sg13g2_decap_8
XFILLER_41_689 VPWR VGND sg13g2_decap_8
XFILLER_40_177 VPWR VGND sg13g2_decap_8
XFILLER_40_199 VPWR VGND sg13g2_decap_8
XFILLER_21_391 VPWR VGND sg13g2_decap_8
XFILLER_5_513 VPWR VGND sg13g2_decap_8
XFILLER_31_85 VPWR VGND sg13g2_decap_8
XFILLER_1_763 VPWR VGND sg13g2_decap_8
XFILLER_49_734 VPWR VGND sg13g2_decap_8
XFILLER_0_262 VPWR VGND sg13g2_decap_8
X_2887__43 VPWR VGND net43 sg13g2_tiehi
XFILLER_0_284 VPWR VGND sg13g2_decap_8
XFILLER_37_929 VPWR VGND sg13g2_decap_8
XFILLER_36_417 VPWR VGND sg13g2_fill_2
XFILLER_48_288 VPWR VGND sg13g2_fill_2
XFILLER_45_940 VPWR VGND sg13g2_decap_8
XFILLER_17_631 VPWR VGND sg13g2_decap_8
XFILLER_32_612 VPWR VGND sg13g2_fill_1
XFILLER_32_667 VPWR VGND sg13g2_decap_8
X_2810_ _1100_ VPWR _1148_ VGND _1099_ _1101_ sg13g2_o21ai_1
XFILLER_13_870 VPWR VGND sg13g2_decap_8
XFILLER_20_829 VPWR VGND sg13g2_fill_1
X_2741_ _1080_ net177 _0027_ VPWR VGND sg13g2_nand2_1
XFILLER_9_896 VPWR VGND sg13g2_decap_8
X_2672_ _1012_ net378 net377 VPWR VGND sg13g2_nand2_2
X_1623_ _1307_ _1306_ _1303_ VPWR VGND sg13g2_nand2b_1
X_1554_ _1152_ VPWR _1239_ VGND _1149_ _1153_ sg13g2_o21ai_1
Xfanout319 net320 net319 VPWR VGND sg13g2_buf_8
Xfanout308 _1038_ net308 VPWR VGND sg13g2_buf_8
.ends
