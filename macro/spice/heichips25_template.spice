* NGSPICE file created from heichips25_template.ext - technology: ihp-sg13g2

* Black-box entry subcircuit for sg13g2_tiehi abstract view
.subckt sg13g2_tiehi VDD VSS L_HI
.ends

* Black-box entry subcircuit for sg13g2_decap_8 abstract view
.subckt sg13g2_decap_8 VDD VSS
.ends

* Black-box entry subcircuit for sg13g2_nor2_1 abstract view
.subckt sg13g2_nor2_1 A B Y VDD VSS
.ends

* Black-box entry subcircuit for sg13g2_a21oi_1 abstract view
.subckt sg13g2_a21oi_1 VSS VDD A1 A2 Y B1
.ends

* Black-box entry subcircuit for sg13g2_fill_1 abstract view
.subckt sg13g2_fill_1 VDD VSS
.ends

* Black-box entry subcircuit for sg13g2_decap_4 abstract view
.subckt sg13g2_decap_4 VDD VSS
.ends

* Black-box entry subcircuit for sg13g2_fill_2 abstract view
.subckt sg13g2_fill_2 VDD VSS
.ends

* Black-box entry subcircuit for sg13g2_o21ai_1 abstract view
.subckt sg13g2_o21ai_1 B1 VDD Y VSS A1 A2
.ends

* Black-box entry subcircuit for sg13g2_nand2_1 abstract view
.subckt sg13g2_nand2_1 Y A B VDD VSS
.ends

* Black-box entry subcircuit for sg13g2_a22oi_1 abstract view
.subckt sg13g2_a22oi_1 Y B1 B2 A2 A1 VDD VSS
.ends

* Black-box entry subcircuit for sg13g2_xor2_1 abstract view
.subckt sg13g2_xor2_1 B A X VDD VSS
.ends

* Black-box entry subcircuit for sg13g2_dlygate4sd3_1 abstract view
.subckt sg13g2_dlygate4sd3_1 A VDD VSS X
.ends

* Black-box entry subcircuit for sg13g2_mux2_1 abstract view
.subckt sg13g2_mux2_1 A0 A1 S X VDD VSS
.ends

* Black-box entry subcircuit for sg13g2_buf_8 abstract view
.subckt sg13g2_buf_8 A X VDD VSS
.ends

* Black-box entry subcircuit for sg13g2_nand2_2 abstract view
.subckt sg13g2_nand2_2 Y A B VDD VSS
.ends

* Black-box entry subcircuit for sg13g2_a21o_1 abstract view
.subckt sg13g2_a21o_1 A2 A1 B1 X VDD VSS
.ends

* Black-box entry subcircuit for sg13g2_nor2b_2 abstract view
.subckt sg13g2_nor2b_2 A B_N Y VDD VSS
.ends

* Black-box entry subcircuit for sg13g2_or2_1 abstract view
.subckt sg13g2_or2_1 VSS VDD X B A
.ends

* Black-box entry subcircuit for sg13g2_xnor2_1 abstract view
.subckt sg13g2_xnor2_1 Y A B VDD VSS
.ends

* Black-box entry subcircuit for sg13g2_and2_1 abstract view
.subckt sg13g2_and2_1 A B X VDD VSS
.ends

* Black-box entry subcircuit for sg13g2_dfrbpq_1 abstract view
.subckt sg13g2_dfrbpq_1 RESET_B VSS VDD D Q CLK
.ends

* Black-box entry subcircuit for sg13g2_nand2b_1 abstract view
.subckt sg13g2_nand2b_1 Y B A_N VDD VSS
.ends

* Black-box entry subcircuit for sg13g2_tielo abstract view
.subckt sg13g2_tielo VDD VSS L_LO
.ends

* Black-box entry subcircuit for sg13g2_nand3_1 abstract view
.subckt sg13g2_nand3_1 B C A Y VDD VSS
.ends

* Black-box entry subcircuit for sg13g2_a221oi_1 abstract view
.subckt sg13g2_a221oi_1 VDD VSS B2 C1 B1 A1 Y A2
.ends

* Black-box entry subcircuit for sg13g2_nor3_1 abstract view
.subckt sg13g2_nor3_1 A B C Y VDD VSS
.ends

* Black-box entry subcircuit for sg13g2_inv_1 abstract view
.subckt sg13g2_inv_1 VDD Y A VSS
.ends

* Black-box entry subcircuit for sg13g2_nor2b_1 abstract view
.subckt sg13g2_nor2b_1 A B_N Y VDD VSS
.ends

* Black-box entry subcircuit for sg13g2_and3_1 abstract view
.subckt sg13g2_and3_1 X A B C VDD VSS
.ends

* Black-box entry subcircuit for sg13g2_nand4_1 abstract view
.subckt sg13g2_nand4_1 B C A Y VDD VSS D
.ends

* Black-box entry subcircuit for sg13g2_dfrbpq_2 abstract view
.subckt sg13g2_dfrbpq_2 RESET_B VSS VDD D Q CLK
.ends

* Black-box entry subcircuit for sg13g2_nand2b_2 abstract view
.subckt sg13g2_nand2b_2 Y B VDD VSS A_N
.ends

* Black-box entry subcircuit for sg13g2_nor3_2 abstract view
.subckt sg13g2_nor3_2 A B C Y VDD VSS
.ends

* Black-box entry subcircuit for sg13g2_inv_4 abstract view
.subckt sg13g2_inv_4 A Y VDD VSS
.ends

* Black-box entry subcircuit for sg13g2_nor4_1 abstract view
.subckt sg13g2_nor4_1 A B C D Y VDD VSS
.ends

* Black-box entry subcircuit for sg13g2_nor2_2 abstract view
.subckt sg13g2_nor2_2 A B Y VDD VSS
.ends

* Black-box entry subcircuit for sg13g2_a21oi_2 abstract view
.subckt sg13g2_a21oi_2 VSS VDD B1 Y A2 A1
.ends

* Black-box entry subcircuit for sg13g2_nand3b_1 abstract view
.subckt sg13g2_nand3b_1 B C Y VDD VSS A_N
.ends

* Black-box entry subcircuit for sg13g2_or3_1 abstract view
.subckt sg13g2_or3_1 A B C X VDD VSS
.ends

* Black-box entry subcircuit for sg13g2_inv_2 abstract view
.subckt sg13g2_inv_2 Y A VDD VSS
.ends

* Black-box entry subcircuit for sg13g2_and4_1 abstract view
.subckt sg13g2_and4_1 A B C D X VDD VSS
.ends

* Black-box entry subcircuit for sg13g2_buf_1 abstract view
.subckt sg13g2_buf_1 A X VDD VSS
.ends

* Black-box entry subcircuit for sg13g2_buf_2 abstract view
.subckt sg13g2_buf_2 A X VDD VSS
.ends

* Black-box entry subcircuit for sg13g2_or4_1 abstract view
.subckt sg13g2_or4_1 A B C D X VDD VSS
.ends

* Black-box entry subcircuit for sg13g2_a21o_2 abstract view
.subckt sg13g2_a21o_2 A2 A1 B1 X VDD VSS
.ends

* Black-box entry subcircuit for sg13g2_and3_2 abstract view
.subckt sg13g2_and3_2 X A B C VDD VSS
.ends

.subckt heichips25_template VGND VPWR clk ena rst_n ui_in[0] ui_in[1] ui_in[2] ui_in[3]
+ ui_in[4] ui_in[5] ui_in[6] ui_in[7] uio_in[0] uio_in[1] uio_in[2] uio_in[3] uio_in[4]
+ uio_in[5] uio_in[6] uio_in[7] uio_oe[0] uio_oe[1] uio_oe[2] uio_oe[3] uio_oe[4]
+ uio_oe[5] uio_oe[6] uio_oe[7] uio_out[0] uio_out[1] uio_out[2] uio_out[3] uio_out[4]
+ uio_out[5] uio_out[6] uio_out[7] uo_out[0] uo_out[1] uo_out[2] uo_out[3] uo_out[4]
+ uo_out[5] uo_out[6] uo_out[7]
X_2878__87 VPWR VGND net87 sg13g2_tiehi
XFILLER_39_288 VPWR VGND sg13g2_decap_8
X_2106_ net508 net286 _0613_ VPWR VGND sg13g2_nor2_1
X_2037_ VGND VPWR _0525_ _0529_ _0559_ _0531_ sg13g2_a21oi_1
XFILLER_36_962 VPWR VGND sg13g2_decap_8
XFILLER_22_133 VPWR VGND sg13g2_decap_8
XFILLER_10_306 VPWR VGND sg13g2_decap_8
XFILLER_11_818 VPWR VGND sg13g2_decap_8
XFILLER_7_7 VPWR VGND sg13g2_decap_8
XFILLER_19_907 VPWR VGND sg13g2_decap_8
XFILLER_13_100 VPWR VGND sg13g2_fill_1
XFILLER_14_601 VPWR VGND sg13g2_decap_4
XFILLER_26_461 VPWR VGND sg13g2_decap_8
XFILLER_27_995 VPWR VGND sg13g2_decap_8
XFILLER_42_954 VPWR VGND sg13g2_decap_8
XFILLER_41_420 VPWR VGND sg13g2_decap_8
XFILLER_14_634 VPWR VGND sg13g2_decap_4
XFILLER_14_645 VPWR VGND sg13g2_decap_8
XFILLER_13_155 VPWR VGND sg13g2_fill_2
XFILLER_41_486 VPWR VGND sg13g2_fill_2
XFILLER_13_199 VPWR VGND sg13g2_fill_2
XFILLER_6_811 VPWR VGND sg13g2_decap_8
XFILLER_10_851 VPWR VGND sg13g2_decap_8
XFILLER_6_888 VPWR VGND sg13g2_decap_8
XFILLER_1_560 VPWR VGND sg13g2_decap_8
XFILLER_49_531 VPWR VGND sg13g2_decap_8
XFILLER_3_67 VPWR VGND sg13g2_decap_8
XFILLER_36_203 VPWR VGND sg13g2_decap_8
XFILLER_18_940 VPWR VGND sg13g2_decap_8
XFILLER_33_910 VPWR VGND sg13g2_decap_8
XFILLER_17_494 VPWR VGND sg13g2_decap_8
XFILLER_33_987 VPWR VGND sg13g2_decap_8
XFILLER_8_181 VPWR VGND sg13g2_fill_2
X_2724_ _1074_ VPWR _1111_ VGND _1073_ _1076_ sg13g2_o21ai_1
X_2655_ net390 VPWR _1044_ VGND net473 net293 sg13g2_o21ai_1
X_1606_ _1306_ _1220_ _1223_ VPWR VGND sg13g2_nand2_1
X_2586_ _0975_ _0972_ _0974_ _0971_ _0945_ VPWR VGND sg13g2_a22oi_1
X_1537_ _1238_ net332 net364 VPWR VGND sg13g2_nand2_1
X_1468_ _1168_ _1132_ _1170_ VPWR VGND sg13g2_xor2_1
XFILLER_27_225 VPWR VGND sg13g2_decap_4
XFILLER_43_729 VPWR VGND sg13g2_decap_8
XFILLER_27_269 VPWR VGND sg13g2_fill_2
XFILLER_24_954 VPWR VGND sg13g2_decap_8
XFILLER_23_442 VPWR VGND sg13g2_decap_8
XFILLER_10_114 VPWR VGND sg13g2_fill_1
XFILLER_7_619 VPWR VGND sg13g2_decap_8
XFILLER_5_4 VPWR VGND sg13g2_decap_8
XFILLER_3_869 VPWR VGND sg13g2_decap_8
Xhold170 falutop.i2c_inst.result\[13\] VPWR VGND net471 sg13g2_dlygate4sd3_1
XFILLER_2_368 VPWR VGND sg13g2_decap_8
Xhold192 _0072_ VPWR VGND net493 sg13g2_dlygate4sd3_1
Xhold181 falutop.i2c_inst.result\[10\] VPWR VGND net482 sg13g2_dlygate4sd3_1
XFILLER_19_715 VPWR VGND sg13g2_decap_8
XFILLER_46_534 VPWR VGND sg13g2_decap_8
XFILLER_37_51 VPWR VGND sg13g2_decap_8
XFILLER_46_567 VPWR VGND sg13g2_fill_2
XFILLER_46_589 VPWR VGND sg13g2_decap_4
XFILLER_14_431 VPWR VGND sg13g2_decap_8
XFILLER_15_943 VPWR VGND sg13g2_decap_8
XFILLER_27_792 VPWR VGND sg13g2_fill_2
XFILLER_30_924 VPWR VGND sg13g2_decap_8
XFILLER_42_795 VPWR VGND sg13g2_fill_1
XFILLER_41_272 VPWR VGND sg13g2_decap_8
XFILLER_6_685 VPWR VGND sg13g2_decap_8
XFILLER_5_173 VPWR VGND sg13g2_decap_8
X_2440_ net430 falutop.data_in\[14\] net312 _0042_ VPWR VGND sg13g2_mux2_1
X_2371_ net220 net314 _0821_ VPWR VGND sg13g2_nor2_1
XFILLER_49_361 VPWR VGND sg13g2_decap_8
XFILLER_25_729 VPWR VGND sg13g2_decap_8
XFILLER_20_423 VPWR VGND sg13g2_decap_8
XFILLER_21_946 VPWR VGND sg13g2_decap_8
Xclkbuf_4_12_0_clk clknet_0_clk clknet_4_12_0_clk VPWR VGND sg13g2_buf_8
XFILLER_20_489 VPWR VGND sg13g2_decap_8
X_2707_ _1095_ _1088_ _1090_ _1082_ _1031_ VPWR VGND sg13g2_a22oi_1
X_2638_ _1020_ _1026_ _1027_ VPWR VGND sg13g2_nor2_1
X_2569_ _0958_ falutop.alu_inst.op\[2\] net369 VPWR VGND sg13g2_nand2_2
XFILLER_12_913 VPWR VGND sg13g2_decap_8
XFILLER_11_423 VPWR VGND sg13g2_decap_8
XFILLER_11_434 VPWR VGND sg13g2_fill_2
XFILLER_23_64 VPWR VGND sg13g2_decap_8
XFILLER_7_416 VPWR VGND sg13g2_decap_8
XFILLER_23_75 VPWR VGND sg13g2_fill_2
XFILLER_48_1008 VPWR VGND sg13g2_decap_8
XFILLER_3_666 VPWR VGND sg13g2_decap_8
XFILLER_2_165 VPWR VGND sg13g2_decap_8
XFILLER_19_501 VPWR VGND sg13g2_decap_4
XFILLER_47_854 VPWR VGND sg13g2_decap_8
XFILLER_0_35 VPWR VGND sg13g2_decap_8
XFILLER_46_364 VPWR VGND sg13g2_decap_4
XFILLER_46_353 VPWR VGND sg13g2_fill_1
XFILLER_19_567 VPWR VGND sg13g2_decap_8
XFILLER_34_537 VPWR VGND sg13g2_decap_8
XFILLER_9_11 VPWR VGND sg13g2_decap_8
X_1940_ VGND VPWR _0422_ _0424_ _0465_ _0421_ sg13g2_a21oi_1
X_1871_ VGND VPWR _0359_ _0367_ _0397_ _0366_ sg13g2_a21oi_1
XFILLER_30_765 VPWR VGND sg13g2_decap_8
XFILLER_7_983 VPWR VGND sg13g2_decap_8
XFILLER_6_482 VPWR VGND sg13g2_decap_8
XFILLER_9_1013 VPWR VGND sg13g2_decap_8
X_2423_ _0864_ net389 net304 VPWR VGND sg13g2_nand2_2
X_2354_ _0808_ VPWR _0809_ VGND net262 net269 sg13g2_o21ai_1
X_2285_ VGND VPWR net377 falutop.div_inst.a\[3\] _0750_ _0749_ sg13g2_a21oi_1
XFILLER_40_518 VPWR VGND sg13g2_decap_8
XFILLER_33_570 VPWR VGND sg13g2_decap_8
XFILLER_20_231 VPWR VGND sg13g2_decap_8
XFILLER_21_754 VPWR VGND sg13g2_decap_8
XFILLER_0_658 VPWR VGND sg13g2_decap_8
XFILLER_48_629 VPWR VGND sg13g2_fill_2
XFILLER_28_375 VPWR VGND sg13g2_decap_8
XFILLER_44_846 VPWR VGND sg13g2_decap_8
XFILLER_43_389 VPWR VGND sg13g2_decap_8
XFILLER_12_732 VPWR VGND sg13g2_fill_1
XFILLER_8_747 VPWR VGND sg13g2_decap_8
XFILLER_7_213 VPWR VGND sg13g2_decap_8
XFILLER_11_264 VPWR VGND sg13g2_fill_1
XFILLER_12_787 VPWR VGND sg13g2_decap_8
XFILLER_7_246 VPWR VGND sg13g2_decap_8
XFILLER_7_224 VPWR VGND sg13g2_fill_2
XFILLER_4_964 VPWR VGND sg13g2_decap_8
XFILLER_3_463 VPWR VGND sg13g2_decap_8
XFILLER_38_128 VPWR VGND sg13g2_decap_8
XFILLER_38_117 VPWR VGND sg13g2_fill_2
X_2070_ _0590_ _0339_ _1104_ _0591_ VPWR VGND sg13g2_a21o_1
XFILLER_35_824 VPWR VGND sg13g2_decap_8
XFILLER_34_312 VPWR VGND sg13g2_decap_4
X_1923_ net330 net347 _0448_ VPWR VGND sg13g2_nor2b_2
XFILLER_30_551 VPWR VGND sg13g2_decap_8
X_1854_ VGND VPWR _0381_ _0380_ _0300_ sg13g2_or2_1
X_1785_ _0281_ _0276_ _0280_ _0313_ VPWR VGND sg13g2_a21o_1
XFILLER_7_780 VPWR VGND sg13g2_decap_8
X_2406_ net387 VPWR _0850_ VGND net379 net297 sg13g2_o21ai_1
X_2337_ _0795_ _0774_ _0775_ VPWR VGND sg13g2_xnor2_1
X_2268_ net375 _0734_ _0736_ VPWR VGND sg13g2_and2_1
XFILLER_26_813 VPWR VGND sg13g2_decap_8
XFILLER_37_161 VPWR VGND sg13g2_decap_4
X_2199_ VGND VPWR net383 _0676_ _0136_ _0677_ sg13g2_a21oi_1
XFILLER_25_345 VPWR VGND sg13g2_decap_4
XFILLER_25_367 VPWR VGND sg13g2_decap_8
XFILLER_34_890 VPWR VGND sg13g2_decap_8
XFILLER_5_728 VPWR VGND sg13g2_decap_8
X_2898__159 VPWR VGND net159 sg13g2_tiehi
XFILLER_4_238 VPWR VGND sg13g2_decap_8
XFILLER_1_945 VPWR VGND sg13g2_decap_8
XFILLER_49_916 VPWR VGND sg13g2_decap_8
XFILLER_0_455 VPWR VGND sg13g2_decap_8
Xhold41 _0016_ VPWR VGND net215 sg13g2_dlygate4sd3_1
Xhold30 _0070_ VPWR VGND net204 sg13g2_dlygate4sd3_1
Xhold74 falutop.i2c_inst.data_in\[15\] VPWR VGND net248 sg13g2_dlygate4sd3_1
Xhold52 falutop.div_inst.val\[5\] VPWR VGND net226 sg13g2_dlygate4sd3_1
Xhold63 _0010_ VPWR VGND net237 sg13g2_dlygate4sd3_1
XFILLER_29_85 VPWR VGND sg13g2_decap_8
Xhold85 falutop.div_inst.i\[1\] VPWR VGND net259 sg13g2_dlygate4sd3_1
Xhold96 falutop.div_inst.val\[4\] VPWR VGND net397 sg13g2_dlygate4sd3_1
XFILLER_45_40 VPWR VGND sg13g2_decap_8
XFILLER_17_846 VPWR VGND sg13g2_fill_2
XFILLER_44_665 VPWR VGND sg13g2_decap_8
XFILLER_16_356 VPWR VGND sg13g2_fill_1
XFILLER_17_879 VPWR VGND sg13g2_decap_4
XFILLER_32_827 VPWR VGND sg13g2_fill_1
XFILLER_32_849 VPWR VGND sg13g2_decap_4
XFILLER_31_348 VPWR VGND sg13g2_decap_4
XFILLER_8_544 VPWR VGND sg13g2_decap_8
XFILLER_6_67 VPWR VGND sg13g2_decap_8
X_1570_ _1270_ net397 _1271_ VPWR VGND sg13g2_xor2_1
XFILLER_4_761 VPWR VGND sg13g2_decap_8
XFILLER_3_260 VPWR VGND sg13g2_fill_1
XFILLER_20_4 VPWR VGND sg13g2_decap_8
X_2122_ _0621_ VPWR _0115_ VGND net290 _0620_ sg13g2_o21ai_1
XFILLER_19_161 VPWR VGND sg13g2_fill_1
X_2053_ net282 VPWR _0575_ VGND net349 _0976_ sg13g2_o21ai_1
XFILLER_35_610 VPWR VGND sg13g2_decap_8
XFILLER_35_621 VPWR VGND sg13g2_fill_2
XFILLER_34_142 VPWR VGND sg13g2_decap_8
XFILLER_35_654 VPWR VGND sg13g2_decap_4
XFILLER_22_315 VPWR VGND sg13g2_decap_8
XFILLER_23_816 VPWR VGND sg13g2_decap_4
XFILLER_34_153 VPWR VGND sg13g2_fill_2
XFILLER_22_326 VPWR VGND sg13g2_fill_2
XFILLER_31_871 VPWR VGND sg13g2_decap_8
X_2886_ net67 VGND VPWR net514 falutop.alu_data_in\[10\] clknet_5_21__leaf_clk sg13g2_dfrbpq_1
X_1906_ _0432_ _0431_ falutop.div_inst.rem\[2\] VPWR VGND sg13g2_nand2b_1
X_1837_ _0364_ _0361_ _0362_ VPWR VGND sg13g2_xnor2_1
X_1768_ _1045_ VPWR _0297_ VGND falutop.div_inst.val\[6\] _0168_ sg13g2_o21ai_1
X_1699_ _0228_ VPWR _0229_ VGND _0943_ _0224_ sg13g2_o21ai_1
XFILLER_44_1000 VPWR VGND sg13g2_decap_8
Xheichips25_template_21 VPWR VGND uo_out[1] sg13g2_tielo
Xheichips25_template_10 VPWR VGND uio_oe[5] sg13g2_tielo
XFILLER_39_982 VPWR VGND sg13g2_decap_8
XFILLER_25_131 VPWR VGND sg13g2_decap_8
XFILLER_26_654 VPWR VGND sg13g2_fill_2
XFILLER_41_624 VPWR VGND sg13g2_decap_8
XFILLER_15_65 VPWR VGND sg13g2_decap_8
XFILLER_15_87 VPWR VGND sg13g2_decap_8
XFILLER_22_871 VPWR VGND sg13g2_decap_8
XFILLER_22_893 VPWR VGND sg13g2_decap_4
XFILLER_5_525 VPWR VGND sg13g2_decap_8
XFILLER_1_742 VPWR VGND sg13g2_decap_8
XFILLER_49_713 VPWR VGND sg13g2_fill_2
X_2913__115 VPWR VGND net115 sg13g2_tiehi
XFILLER_0_252 VPWR VGND sg13g2_decap_8
XFILLER_48_212 VPWR VGND sg13g2_fill_1
XFILLER_36_418 VPWR VGND sg13g2_fill_1
XFILLER_45_952 VPWR VGND sg13g2_decap_8
XFILLER_44_473 VPWR VGND sg13g2_decap_8
XFILLER_31_145 VPWR VGND sg13g2_decap_8
XFILLER_32_679 VPWR VGND sg13g2_decap_8
XFILLER_9_831 VPWR VGND sg13g2_decap_8
X_2740_ VGND VPWR _0985_ _0996_ _1127_ _0986_ sg13g2_a21oi_1
Xclkbuf_5_17__f_clk clknet_4_8_0_clk clknet_5_17__leaf_clk VPWR VGND sg13g2_buf_8
X_2671_ _1056_ _1057_ _0960_ _1059_ VPWR VGND sg13g2_nand3_1
X_1622_ net283 VPWR _0153_ VGND net353 net271 sg13g2_o21ai_1
X_1553_ VGND VPWR _1254_ _1253_ _1237_ sg13g2_or2_1
XFILLER_28_1017 VPWR VGND sg13g2_decap_8
X_1484_ VPWR VGND _1177_ _1185_ _1176_ _1088_ _1186_ _1175_ sg13g2_a221oi_1
Xfanout309 _0920_ net309 VPWR VGND sg13g2_buf_8
XFILLER_28_1028 VPWR VGND sg13g2_fill_1
XFILLER_39_267 VPWR VGND sg13g2_decap_8
XFILLER_27_407 VPWR VGND sg13g2_decap_8
XFILLER_28_919 VPWR VGND sg13g2_decap_8
X_2105_ VGND VPWR _0718_ net284 _0107_ _0612_ sg13g2_a21oi_1
X_2036_ _0533_ VPWR _0558_ VGND _0523_ _0534_ sg13g2_o21ai_1
XFILLER_36_941 VPWR VGND sg13g2_decap_8
X_2784__101 VPWR VGND net101 sg13g2_tiehi
XFILLER_35_484 VPWR VGND sg13g2_decap_8
XFILLER_11_1021 VPWR VGND sg13g2_decap_8
X_2869_ net116 VGND VPWR net452 falutop.i2c_inst.result\[11\] clknet_5_25__leaf_clk
+ sg13g2_dfrbpq_1
XFILLER_26_440 VPWR VGND sg13g2_decap_8
XFILLER_27_974 VPWR VGND sg13g2_decap_8
XFILLER_42_933 VPWR VGND sg13g2_decap_8
XFILLER_13_123 VPWR VGND sg13g2_decap_8
XFILLER_26_97 VPWR VGND sg13g2_decap_4
XFILLER_14_668 VPWR VGND sg13g2_decap_8
XFILLER_42_41 VPWR VGND sg13g2_decap_8
XFILLER_41_498 VPWR VGND sg13g2_decap_8
XFILLER_10_830 VPWR VGND sg13g2_decap_8
XFILLER_6_867 VPWR VGND sg13g2_decap_8
XFILLER_3_46 VPWR VGND sg13g2_decap_8
XFILLER_49_510 VPWR VGND sg13g2_decap_8
XFILLER_49_587 VPWR VGND sg13g2_decap_8
XFILLER_45_782 VPWR VGND sg13g2_decap_8
XFILLER_17_451 VPWR VGND sg13g2_fill_2
XFILLER_17_473 VPWR VGND sg13g2_decap_8
XFILLER_18_996 VPWR VGND sg13g2_decap_8
XFILLER_44_270 VPWR VGND sg13g2_decap_8
XFILLER_20_605 VPWR VGND sg13g2_fill_1
XFILLER_33_966 VPWR VGND sg13g2_decap_8
XFILLER_20_638 VPWR VGND sg13g2_decap_4
XFILLER_32_498 VPWR VGND sg13g2_decap_8
X_2723_ _1110_ net337 net330 VPWR VGND sg13g2_nand2_1
X_2654_ _1042_ VPWR _1043_ VGND falutop.div_inst.val\[0\] net303 sg13g2_o21ai_1
X_1605_ _1305_ net333 net321 VPWR VGND sg13g2_nand2_1
X_2585_ _0973_ VPWR _0974_ VGND _0720_ net349 sg13g2_o21ai_1
X_1536_ VGND VPWR _1164_ _1167_ _1237_ _1163_ sg13g2_a21oi_1
X_1467_ _1132_ _1168_ _1169_ VPWR VGND sg13g2_nor2_1
XFILLER_27_204 VPWR VGND sg13g2_decap_8
XFILLER_27_248 VPWR VGND sg13g2_decap_8
XFILLER_36_771 VPWR VGND sg13g2_decap_8
X_2019_ _0506_ _0541_ _0542_ VPWR VGND sg13g2_nor2_1
XFILLER_23_421 VPWR VGND sg13g2_decap_8
XFILLER_24_933 VPWR VGND sg13g2_decap_8
XFILLER_11_627 VPWR VGND sg13g2_decap_8
XFILLER_10_159 VPWR VGND sg13g2_fill_2
XFILLER_12_11 VPWR VGND sg13g2_decap_4
XFILLER_12_33 VPWR VGND sg13g2_decap_8
XFILLER_12_44 VPWR VGND sg13g2_decap_8
X_2787__98 VPWR VGND net98 sg13g2_tiehi
Xhold171 _0092_ VPWR VGND net472 sg13g2_dlygate4sd3_1
XFILLER_3_848 VPWR VGND sg13g2_decap_8
XFILLER_2_347 VPWR VGND sg13g2_decap_8
Xhold160 _0061_ VPWR VGND net461 sg13g2_dlygate4sd3_1
Xhold193 falutop.div_inst.rem\[2\] VPWR VGND net494 sg13g2_dlygate4sd3_1
Xhold182 _0089_ VPWR VGND net483 sg13g2_dlygate4sd3_1
XFILLER_46_513 VPWR VGND sg13g2_decap_8
XFILLER_37_30 VPWR VGND sg13g2_decap_8
XFILLER_18_204 VPWR VGND sg13g2_decap_8
XFILLER_19_738 VPWR VGND sg13g2_decap_8
XFILLER_15_922 VPWR VGND sg13g2_decap_8
XFILLER_34_719 VPWR VGND sg13g2_fill_1
XFILLER_14_410 VPWR VGND sg13g2_decap_8
XFILLER_42_774 VPWR VGND sg13g2_decap_8
XFILLER_30_903 VPWR VGND sg13g2_decap_8
X_2880__83 VPWR VGND net83 sg13g2_tiehi
XFILLER_15_999 VPWR VGND sg13g2_decap_8
XFILLER_6_664 VPWR VGND sg13g2_decap_8
X_2919__121 VPWR VGND net121 sg13g2_tiehi
X_2370_ net264 falutop.i2c_inst.op\[1\] net314 _0017_ VPWR VGND sg13g2_mux2_1
XFILLER_37_513 VPWR VGND sg13g2_decap_4
XFILLER_37_557 VPWR VGND sg13g2_decap_8
XFILLER_37_579 VPWR VGND sg13g2_decap_8
XFILLER_18_771 VPWR VGND sg13g2_decap_8
X_2781__104 VPWR VGND net104 sg13g2_tiehi
XFILLER_21_925 VPWR VGND sg13g2_decap_8
XFILLER_32_251 VPWR VGND sg13g2_decap_8
XFILLER_32_262 VPWR VGND sg13g2_fill_1
XFILLER_20_457 VPWR VGND sg13g2_fill_1
X_2706_ VPWR VGND _0933_ _1086_ _1080_ net308 _1094_ _1017_ sg13g2_a221oi_1
X_2637_ VGND VPWR _0987_ _1023_ _1026_ _1025_ sg13g2_a21oi_1
X_2568_ _0957_ _0919_ _0955_ VPWR VGND sg13g2_nand2_1
X_2499_ VGND VPWR _0706_ net301 _0065_ _0901_ sg13g2_a21oi_1
X_1519_ _1220_ _1219_ _1218_ VPWR VGND sg13g2_nand2b_1
XFILLER_28_502 VPWR VGND sg13g2_decap_8
XFILLER_11_402 VPWR VGND sg13g2_decap_8
XFILLER_11_413 VPWR VGND sg13g2_fill_2
XFILLER_23_273 VPWR VGND sg13g2_decap_8
XFILLER_8_929 VPWR VGND sg13g2_decap_8
XFILLER_12_969 VPWR VGND sg13g2_decap_8
XFILLER_20_991 VPWR VGND sg13g2_decap_8
XFILLER_3_645 VPWR VGND sg13g2_decap_8
XFILLER_2_144 VPWR VGND sg13g2_decap_8
X_2838__174 VPWR VGND net174 sg13g2_tiehi
XFILLER_47_833 VPWR VGND sg13g2_decap_8
XFILLER_46_332 VPWR VGND sg13g2_decap_8
XFILLER_0_14 VPWR VGND sg13g2_decap_8
XFILLER_19_535 VPWR VGND sg13g2_decap_8
XFILLER_19_546 VPWR VGND sg13g2_fill_1
XFILLER_42_582 VPWR VGND sg13g2_decap_8
XFILLER_14_251 VPWR VGND sg13g2_fill_2
X_1870_ _0396_ _0350_ _0394_ VPWR VGND sg13g2_xnor2_1
XFILLER_9_67 VPWR VGND sg13g2_decap_8
XFILLER_30_733 VPWR VGND sg13g2_decap_8
XFILLER_30_788 VPWR VGND sg13g2_fill_1
XFILLER_7_962 VPWR VGND sg13g2_decap_8
XFILLER_6_461 VPWR VGND sg13g2_decap_8
X_2422_ _0714_ net303 _0863_ VPWR VGND sg13g2_nor2_1
X_2353_ _0808_ net269 _0807_ VPWR VGND sg13g2_nand2_1
XFILLER_38_800 VPWR VGND sg13g2_decap_4
X_2284_ _0704_ net377 _0749_ VPWR VGND sg13g2_nor2_1
XFILLER_25_527 VPWR VGND sg13g2_decap_8
XFILLER_21_777 VPWR VGND sg13g2_decap_8
X_1999_ _1307_ _0350_ _0488_ _0522_ VPWR VGND sg13g2_nor3_1
XFILLER_0_637 VPWR VGND sg13g2_decap_8
XFILLER_29_833 VPWR VGND sg13g2_decap_8
XFILLER_29_844 VPWR VGND sg13g2_fill_2
XFILLER_44_825 VPWR VGND sg13g2_decap_8
XFILLER_16_505 VPWR VGND sg13g2_decap_4
XFILLER_16_516 VPWR VGND sg13g2_decap_8
XFILLER_18_76 VPWR VGND sg13g2_fill_2
XFILLER_28_343 VPWR VGND sg13g2_decap_4
XFILLER_29_866 VPWR VGND sg13g2_decap_8
XFILLER_43_335 VPWR VGND sg13g2_decap_4
XFILLER_43_313 VPWR VGND sg13g2_decap_8
XFILLER_16_527 VPWR VGND sg13g2_fill_1
XFILLER_18_98 VPWR VGND sg13g2_fill_1
X_2909__131 VPWR VGND net131 sg13g2_tiehi
XFILLER_24_593 VPWR VGND sg13g2_decap_8
XFILLER_8_726 VPWR VGND sg13g2_decap_8
XFILLER_12_766 VPWR VGND sg13g2_decap_8
XFILLER_4_943 VPWR VGND sg13g2_decap_8
XFILLER_3_442 VPWR VGND sg13g2_decap_8
Xclkbuf_4_11_0_clk clknet_0_clk clknet_4_11_0_clk VPWR VGND sg13g2_buf_8
XFILLER_19_376 VPWR VGND sg13g2_decap_4
XFILLER_22_519 VPWR VGND sg13g2_decap_8
X_2923__117 VPWR VGND net117 sg13g2_tiehi
X_1922_ _0447_ net323 net349 VPWR VGND sg13g2_nand2_1
X_1853_ _0380_ _0335_ _0378_ VPWR VGND sg13g2_nand2_1
X_1784_ _0310_ _0304_ _0312_ VPWR VGND sg13g2_xor2_1
XFILLER_41_0 VPWR VGND sg13g2_decap_8
X_2405_ VGND VPWR net297 _0848_ _0023_ _0849_ sg13g2_a21oi_1
X_2336_ _0794_ net236 _0738_ VPWR VGND sg13g2_nand2_1
X_2267_ VPWR _0735_ _0734_ VGND sg13g2_inv_1
XFILLER_38_663 VPWR VGND sg13g2_decap_8
X_2198_ net391 VPWR _0677_ VGND net416 _0676_ sg13g2_o21ai_1
XFILLER_38_1008 VPWR VGND sg13g2_decap_8
XFILLER_41_817 VPWR VGND sg13g2_decap_8
XFILLER_13_508 VPWR VGND sg13g2_fill_2
XFILLER_40_349 VPWR VGND sg13g2_decap_8
XFILLER_21_585 VPWR VGND sg13g2_decap_8
XFILLER_5_707 VPWR VGND sg13g2_decap_8
XFILLER_20_22 VPWR VGND sg13g2_decap_8
XFILLER_1_924 VPWR VGND sg13g2_decap_8
XFILLER_20_88 VPWR VGND sg13g2_decap_4
XFILLER_0_434 VPWR VGND sg13g2_decap_8
Xhold20 falutop.div_inst.val\[6\] VPWR VGND net194 sg13g2_dlygate4sd3_1
Xhold31 falutop.div_inst.a\[4\] VPWR VGND net205 sg13g2_dlygate4sd3_1
Xhold53 _0068_ VPWR VGND net227 sg13g2_dlygate4sd3_1
Xhold42 falutop.div_inst.acc\[1\] VPWR VGND net216 sg13g2_dlygate4sd3_1
Xhold64 falutop.div_inst.b1\[0\] VPWR VGND net238 sg13g2_dlygate4sd3_1
XFILLER_29_64 VPWR VGND sg13g2_decap_8
Xhold75 _0043_ VPWR VGND net249 sg13g2_dlygate4sd3_1
Xhold86 _0895_ VPWR VGND net260 sg13g2_dlygate4sd3_1
Xhold97 _0903_ VPWR VGND net398 sg13g2_dlygate4sd3_1
XFILLER_17_803 VPWR VGND sg13g2_decap_8
XFILLER_21_1023 VPWR VGND sg13g2_decap_4
XFILLER_29_674 VPWR VGND sg13g2_decap_4
XFILLER_44_644 VPWR VGND sg13g2_decap_8
XFILLER_43_132 VPWR VGND sg13g2_fill_1
XFILLER_43_121 VPWR VGND sg13g2_decap_8
XFILLER_32_806 VPWR VGND sg13g2_decap_8
XFILLER_44_688 VPWR VGND sg13g2_decap_8
XFILLER_43_165 VPWR VGND sg13g2_decap_4
XFILLER_31_316 VPWR VGND sg13g2_decap_8
XFILLER_43_198 VPWR VGND sg13g2_decap_8
XFILLER_12_530 VPWR VGND sg13g2_decap_8
XFILLER_31_327 VPWR VGND sg13g2_fill_1
XFILLER_12_541 VPWR VGND sg13g2_fill_1
XFILLER_12_552 VPWR VGND sg13g2_decap_8
XFILLER_8_523 VPWR VGND sg13g2_decap_8
XFILLER_6_46 VPWR VGND sg13g2_decap_8
XFILLER_4_740 VPWR VGND sg13g2_decap_8
XFILLER_6_1028 VPWR VGND sg13g2_fill_1
X_2121_ _0621_ net182 net290 VPWR VGND sg13g2_nand2_1
XFILLER_13_4 VPWR VGND sg13g2_decap_4
X_2052_ net319 net272 _0574_ VPWR VGND sg13g2_nor2_1
XFILLER_48_994 VPWR VGND sg13g2_decap_8
XFILLER_47_493 VPWR VGND sg13g2_fill_1
XFILLER_34_121 VPWR VGND sg13g2_decap_8
XFILLER_35_666 VPWR VGND sg13g2_decap_8
X_2885_ net69 VGND VPWR net511 falutop.alu_data_in\[9\] clknet_5_23__leaf_clk sg13g2_dfrbpq_1
X_1905_ net371 VPWR _0431_ VGND falutop.div_inst.rem\[1\] falutop.div_inst.rem\[0\]
+ sg13g2_o21ai_1
X_1836_ _0361_ _0362_ _0363_ VPWR VGND sg13g2_nor2b_1
X_1767_ net278 VPWR _0296_ VGND _0257_ _0295_ sg13g2_o21ai_1
X_1698_ _0994_ _0226_ _0227_ _0228_ VPWR VGND sg13g2_nor3_1
X_2319_ _0779_ falutop.div_inst.b1\[4\] falutop.div_inst.acc\[4\] VPWR VGND sg13g2_xnor2_1
Xheichips25_template_11 VPWR VGND uio_oe[6] sg13g2_tielo
XFILLER_39_961 VPWR VGND sg13g2_decap_8
Xheichips25_template_22 VPWR VGND uo_out[2] sg13g2_tielo
XFILLER_25_121 VPWR VGND sg13g2_fill_1
XFILLER_41_603 VPWR VGND sg13g2_decap_8
XFILLER_13_316 VPWR VGND sg13g2_fill_2
XFILLER_25_198 VPWR VGND sg13g2_decap_4
XFILLER_40_168 VPWR VGND sg13g2_decap_8
XFILLER_5_504 VPWR VGND sg13g2_decap_8
XFILLER_31_76 VPWR VGND sg13g2_fill_1
XFILLER_1_721 VPWR VGND sg13g2_decap_8
XFILLER_0_231 VPWR VGND sg13g2_decap_8
XFILLER_1_798 VPWR VGND sg13g2_decap_8
XFILLER_49_769 VPWR VGND sg13g2_decap_8
XFILLER_45_931 VPWR VGND sg13g2_decap_8
XFILLER_29_482 VPWR VGND sg13g2_decap_8
XFILLER_44_430 VPWR VGND sg13g2_decap_4
XFILLER_9_810 VPWR VGND sg13g2_decap_8
XFILLER_13_894 VPWR VGND sg13g2_decap_8
XFILLER_9_887 VPWR VGND sg13g2_decap_8
X_2670_ VPWR _1058_ _1057_ VGND sg13g2_inv_1
XFILLER_8_386 VPWR VGND sg13g2_fill_2
X_1621_ _0152_ net281 _0150_ _0151_ VPWR VGND sg13g2_and3_1
X_1552_ _1253_ _1244_ _1252_ VPWR VGND sg13g2_xnor2_1
X_1483_ _1181_ _1182_ _1180_ _1185_ VPWR VGND _1184_ sg13g2_nand4_1
XFILLER_39_213 VPWR VGND sg13g2_decap_8
X_2104_ net513 net284 _0612_ VPWR VGND sg13g2_nor2_1
XFILLER_48_791 VPWR VGND sg13g2_decap_8
XFILLER_36_920 VPWR VGND sg13g2_decap_8
X_2035_ _0557_ _0540_ _0545_ VPWR VGND sg13g2_nand2_1
XFILLER_47_290 VPWR VGND sg13g2_decap_8
XFILLER_23_603 VPWR VGND sg13g2_decap_8
XFILLER_35_474 VPWR VGND sg13g2_fill_1
XFILLER_36_997 VPWR VGND sg13g2_decap_8
XFILLER_22_113 VPWR VGND sg13g2_decap_8
XFILLER_23_658 VPWR VGND sg13g2_decap_4
XFILLER_23_669 VPWR VGND sg13g2_fill_1
XFILLER_30_190 VPWR VGND sg13g2_decap_8
XFILLER_11_1000 VPWR VGND sg13g2_decap_8
X_2868_ net118 VGND VPWR net483 falutop.i2c_inst.result\[10\] clknet_5_28__leaf_clk
+ sg13g2_dfrbpq_1
X_2799_ net78 VGND VPWR net177 falutop.i2c_inst.state\[0\] clknet_5_15__leaf_clk sg13g2_dfrbpq_2
X_1819_ _0346_ _0309_ _0311_ VPWR VGND sg13g2_nand2_1
XFILLER_2_529 VPWR VGND sg13g2_decap_8
XFILLER_46_728 VPWR VGND sg13g2_decap_4
Xclkbuf_5_23__f_clk clknet_4_11_0_clk clknet_5_23__leaf_clk VPWR VGND sg13g2_buf_8
XFILLER_27_953 VPWR VGND sg13g2_decap_8
XFILLER_42_912 VPWR VGND sg13g2_decap_8
XFILLER_41_400 VPWR VGND sg13g2_fill_2
XFILLER_26_76 VPWR VGND sg13g2_decap_8
XFILLER_26_496 VPWR VGND sg13g2_fill_2
XFILLER_42_989 VPWR VGND sg13g2_decap_8
XFILLER_41_455 VPWR VGND sg13g2_decap_8
XFILLER_41_488 VPWR VGND sg13g2_fill_1
XFILLER_42_64 VPWR VGND sg13g2_fill_2
XFILLER_6_846 VPWR VGND sg13g2_decap_8
XFILLER_10_886 VPWR VGND sg13g2_decap_8
XFILLER_3_25 VPWR VGND sg13g2_decap_8
XFILLER_1_595 VPWR VGND sg13g2_decap_8
XFILLER_49_566 VPWR VGND sg13g2_decap_8
XFILLER_37_706 VPWR VGND sg13g2_decap_8
XFILLER_3_1009 VPWR VGND sg13g2_decap_8
XFILLER_37_717 VPWR VGND sg13g2_fill_1
XFILLER_17_430 VPWR VGND sg13g2_decap_8
XFILLER_45_761 VPWR VGND sg13g2_decap_8
XFILLER_18_975 VPWR VGND sg13g2_decap_8
XFILLER_33_945 VPWR VGND sg13g2_decap_8
XFILLER_32_466 VPWR VGND sg13g2_decap_8
XFILLER_13_680 VPWR VGND sg13g2_fill_1
XFILLER_12_190 VPWR VGND sg13g2_fill_1
X_2722_ VGND VPWR _0718_ net271 _1109_ _1108_ sg13g2_a21oi_1
XFILLER_8_150 VPWR VGND sg13g2_decap_8
XFILLER_9_684 VPWR VGND sg13g2_decap_8
X_2653_ _0981_ _0998_ _0961_ _1042_ VPWR VGND _1041_ sg13g2_nand4_1
X_1604_ _1304_ _1256_ _1303_ VPWR VGND sg13g2_xnor2_1
X_2584_ _0973_ net318 _0724_ VPWR VGND sg13g2_nand2_1
X_1535_ _1169_ _1171_ _1236_ VPWR VGND sg13g2_nor2_1
X_1466_ _1168_ _1164_ _1167_ VPWR VGND sg13g2_xnor2_1
XFILLER_41_1026 VPWR VGND sg13g2_fill_2
X_2018_ _0539_ _0538_ _0541_ VPWR VGND sg13g2_xor2_1
XFILLER_24_912 VPWR VGND sg13g2_decap_8
XFILLER_36_761 VPWR VGND sg13g2_fill_2
XFILLER_35_271 VPWR VGND sg13g2_fill_2
XFILLER_11_606 VPWR VGND sg13g2_decap_8
XFILLER_24_989 VPWR VGND sg13g2_decap_8
XFILLER_23_477 VPWR VGND sg13g2_fill_2
XFILLER_10_138 VPWR VGND sg13g2_decap_8
XFILLER_6_109 VPWR VGND sg13g2_fill_1
XFILLER_3_827 VPWR VGND sg13g2_decap_8
XFILLER_2_326 VPWR VGND sg13g2_decap_8
Xhold161 falutop.div_inst.b1\[4\] VPWR VGND net462 sg13g2_dlygate4sd3_1
Xhold150 falutop.i2c_inst.result\[11\] VPWR VGND net451 sg13g2_dlygate4sd3_1
Xhold194 falutop.div_inst.rem\[4\] VPWR VGND net495 sg13g2_dlygate4sd3_1
Xhold172 falutop.i2c_inst.result\[0\] VPWR VGND net473 sg13g2_dlygate4sd3_1
Xhold183 falutop.i2c_inst.result\[3\] VPWR VGND net484 sg13g2_dlygate4sd3_1
XFILLER_15_901 VPWR VGND sg13g2_decap_8
XFILLER_27_761 VPWR VGND sg13g2_decap_8
XFILLER_34_709 VPWR VGND sg13g2_fill_2
XFILLER_27_794 VPWR VGND sg13g2_fill_1
XFILLER_42_764 VPWR VGND sg13g2_decap_4
XFILLER_42_742 VPWR VGND sg13g2_fill_2
XFILLER_15_978 VPWR VGND sg13g2_decap_8
XFILLER_18_1017 VPWR VGND sg13g2_decap_8
XFILLER_18_1028 VPWR VGND sg13g2_fill_1
XFILLER_14_488 VPWR VGND sg13g2_decap_8
XFILLER_30_959 VPWR VGND sg13g2_decap_8
XFILLER_6_643 VPWR VGND sg13g2_decap_8
XFILLER_10_683 VPWR VGND sg13g2_decap_8
XFILLER_2_893 VPWR VGND sg13g2_decap_8
XFILLER_1_392 VPWR VGND sg13g2_decap_8
XFILLER_18_750 VPWR VGND sg13g2_decap_4
XFILLER_17_271 VPWR VGND sg13g2_fill_2
XFILLER_24_219 VPWR VGND sg13g2_decap_8
XFILLER_21_904 VPWR VGND sg13g2_decap_8
XFILLER_32_230 VPWR VGND sg13g2_decap_8
XFILLER_33_764 VPWR VGND sg13g2_decap_8
XFILLER_33_797 VPWR VGND sg13g2_decap_8
XFILLER_20_447 VPWR VGND sg13g2_decap_4
XFILLER_9_481 VPWR VGND sg13g2_fill_2
X_2705_ VGND VPWR _0984_ _1031_ _1093_ _1020_ sg13g2_a21oi_1
X_2636_ net315 _1024_ _1025_ VPWR VGND sg13g2_nor2_1
XFILLER_0_819 VPWR VGND sg13g2_decap_8
X_2567_ VGND VPWR _0956_ _0955_ _0919_ sg13g2_or2_1
X_2498_ net389 VPWR _0901_ VGND falutop.div_inst.val\[2\] net301 sg13g2_o21ai_1
X_1518_ _1197_ VPWR _1219_ VGND _1196_ _1199_ sg13g2_o21ai_1
XFILLER_43_517 VPWR VGND sg13g2_decap_8
XFILLER_43_539 VPWR VGND sg13g2_decap_8
XFILLER_15_219 VPWR VGND sg13g2_decap_8
XFILLER_24_753 VPWR VGND sg13g2_fill_2
XFILLER_23_252 VPWR VGND sg13g2_decap_8
XFILLER_24_775 VPWR VGND sg13g2_fill_2
XFILLER_8_908 VPWR VGND sg13g2_decap_8
XFILLER_12_948 VPWR VGND sg13g2_decap_8
XFILLER_23_22 VPWR VGND sg13g2_decap_8
XFILLER_23_33 VPWR VGND sg13g2_fill_2
XFILLER_23_44 VPWR VGND sg13g2_decap_4
XFILLER_20_970 VPWR VGND sg13g2_decap_8
XFILLER_3_624 VPWR VGND sg13g2_decap_8
XFILLER_2_123 VPWR VGND sg13g2_decap_8
XFILLER_24_1010 VPWR VGND sg13g2_decap_8
XFILLER_47_812 VPWR VGND sg13g2_decap_8
XFILLER_48_85 VPWR VGND sg13g2_decap_8
XFILLER_48_96 VPWR VGND sg13g2_fill_2
XFILLER_19_525 VPWR VGND sg13g2_decap_4
XFILLER_47_889 VPWR VGND sg13g2_decap_8
XFILLER_46_344 VPWR VGND sg13g2_decap_8
XFILLER_46_388 VPWR VGND sg13g2_decap_8
XFILLER_15_742 VPWR VGND sg13g2_decap_8
XFILLER_27_591 VPWR VGND sg13g2_fill_2
XFILLER_42_561 VPWR VGND sg13g2_decap_8
XFILLER_14_274 VPWR VGND sg13g2_decap_4
XFILLER_15_786 VPWR VGND sg13g2_decap_8
XFILLER_30_712 VPWR VGND sg13g2_decap_8
XFILLER_9_46 VPWR VGND sg13g2_decap_8
XFILLER_10_480 VPWR VGND sg13g2_decap_8
XFILLER_7_941 VPWR VGND sg13g2_decap_8
XFILLER_31_1025 VPWR VGND sg13g2_decap_4
XFILLER_10_491 VPWR VGND sg13g2_fill_1
XFILLER_6_440 VPWR VGND sg13g2_decap_8
X_2421_ _0862_ net304 VPWR VGND net175 sg13g2_nand2b_2
X_2352_ _0807_ _0780_ _0781_ VPWR VGND sg13g2_xnor2_1
X_2283_ VGND VPWR net275 _0747_ _0002_ _0748_ sg13g2_a21oi_1
XFILLER_2_690 VPWR VGND sg13g2_decap_8
XFILLER_38_812 VPWR VGND sg13g2_fill_1
XFILLER_38_834 VPWR VGND sg13g2_decap_8
XFILLER_38_889 VPWR VGND sg13g2_decap_8
XFILLER_37_344 VPWR VGND sg13g2_decap_8
X_2836__29 VPWR VGND net29 sg13g2_tiehi
XFILLER_37_399 VPWR VGND sg13g2_decap_8
XFILLER_21_723 VPWR VGND sg13g2_fill_2
X_1998_ VPWR _0521_ _0520_ VGND sg13g2_inv_1
X_2619_ falutop.alu_inst.op\[2\] net369 _0959_ _1008_ VPWR VGND sg13g2_nor3_2
XFILLER_0_616 VPWR VGND sg13g2_decap_8
XFILLER_29_801 VPWR VGND sg13g2_decap_8
XFILLER_18_44 VPWR VGND sg13g2_decap_4
XFILLER_34_54 VPWR VGND sg13g2_fill_2
XFILLER_11_211 VPWR VGND sg13g2_fill_2
XFILLER_24_583 VPWR VGND sg13g2_decap_4
XFILLER_34_76 VPWR VGND sg13g2_decap_8
XFILLER_8_705 VPWR VGND sg13g2_decap_8
XFILLER_4_922 VPWR VGND sg13g2_decap_8
XFILLER_3_421 VPWR VGND sg13g2_decap_8
XFILLER_4_999 VPWR VGND sg13g2_decap_8
XFILLER_1_0 VPWR VGND sg13g2_decap_8
XFILLER_39_609 VPWR VGND sg13g2_decap_8
XFILLER_3_498 VPWR VGND sg13g2_decap_8
Xfanout290 _0864_ net290 VPWR VGND sg13g2_buf_8
XFILLER_47_664 VPWR VGND sg13g2_decap_8
XFILLER_47_642 VPWR VGND sg13g2_fill_2
XFILLER_19_344 VPWR VGND sg13g2_decap_8
XFILLER_19_355 VPWR VGND sg13g2_fill_2
XFILLER_46_185 VPWR VGND sg13g2_fill_2
XFILLER_46_152 VPWR VGND sg13g2_decap_8
XFILLER_34_347 VPWR VGND sg13g2_decap_8
XFILLER_35_859 VPWR VGND sg13g2_decap_4
XFILLER_15_561 VPWR VGND sg13g2_decap_4
XFILLER_43_892 VPWR VGND sg13g2_decap_8
X_1921_ _0406_ VPWR _0446_ VGND _0403_ _0407_ sg13g2_o21ai_1
XFILLER_15_583 VPWR VGND sg13g2_fill_2
XFILLER_30_520 VPWR VGND sg13g2_fill_1
X_1852_ _0334_ _0378_ _0379_ VPWR VGND sg13g2_nor2_1
X_1783_ _0311_ _0304_ _0310_ VPWR VGND sg13g2_nand2b_1
X_2404_ net394 VPWR _0849_ VGND net380 net297 sg13g2_o21ai_1
XFILLER_34_0 VPWR VGND sg13g2_decap_4
X_2335_ _0790_ VPWR _0009_ VGND _0731_ _0793_ sg13g2_o21ai_1
X_2266_ _0734_ _0732_ _0733_ VPWR VGND sg13g2_nand2_2
XFILLER_29_119 VPWR VGND sg13g2_decap_4
X_2197_ _0840_ _0675_ _0676_ VPWR VGND sg13g2_nor2_1
Xclkbuf_5_4__f_clk clknet_4_2_0_clk clknet_5_4__leaf_clk VPWR VGND sg13g2_buf_8
XFILLER_26_804 VPWR VGND sg13g2_fill_2
XFILLER_1_91 VPWR VGND sg13g2_decap_8
XFILLER_40_328 VPWR VGND sg13g2_decap_8
XFILLER_21_553 VPWR VGND sg13g2_decap_8
XFILLER_1_903 VPWR VGND sg13g2_decap_8
XFILLER_20_67 VPWR VGND sg13g2_decap_8
XFILLER_0_413 VPWR VGND sg13g2_decap_8
Xhold21 falutop.div_inst.quo\[2\] VPWR VGND net195 sg13g2_dlygate4sd3_1
Xhold10 falutop.div_inst.a\[6\] VPWR VGND net184 sg13g2_dlygate4sd3_1
Xhold32 _0117_ VPWR VGND net206 sg13g2_dlygate4sd3_1
Xhold54 falutop.div_inst.acc\[7\] VPWR VGND net228 sg13g2_dlygate4sd3_1
Xhold43 _0008_ VPWR VGND net217 sg13g2_dlygate4sd3_1
XFILLER_21_1002 VPWR VGND sg13g2_decap_8
Xhold65 _0896_ VPWR VGND net239 sg13g2_dlygate4sd3_1
Xhold76 falutop.i2c_inst.op\[0\] VPWR VGND net250 sg13g2_dlygate4sd3_1
Xhold87 _0052_ VPWR VGND net261 sg13g2_dlygate4sd3_1
Xhold98 _0067_ VPWR VGND net399 sg13g2_dlygate4sd3_1
XFILLER_17_848 VPWR VGND sg13g2_fill_1
X_2808__62 VPWR VGND net62 sg13g2_tiehi
XFILLER_43_144 VPWR VGND sg13g2_decap_8
XFILLER_16_369 VPWR VGND sg13g2_decap_8
XFILLER_40_840 VPWR VGND sg13g2_fill_1
XFILLER_40_884 VPWR VGND sg13g2_decap_8
XFILLER_8_579 VPWR VGND sg13g2_decap_8
XFILLER_6_25 VPWR VGND sg13g2_decap_8
XFILLER_4_796 VPWR VGND sg13g2_decap_8
XFILLER_3_295 VPWR VGND sg13g2_decap_8
XFILLER_6_1007 VPWR VGND sg13g2_decap_8
XFILLER_0_980 VPWR VGND sg13g2_decap_8
X_2120_ _0619_ falutop.data_in\[10\] _0620_ VPWR VGND sg13g2_xor2_1
XFILLER_48_973 VPWR VGND sg13g2_decap_8
X_2051_ _0573_ net280 _0571_ _0572_ VPWR VGND sg13g2_and3_1
XFILLER_47_483 VPWR VGND sg13g2_fill_1
XFILLER_19_152 VPWR VGND sg13g2_decap_8
XFILLER_19_174 VPWR VGND sg13g2_fill_2
XFILLER_35_634 VPWR VGND sg13g2_decap_8
XFILLER_34_166 VPWR VGND sg13g2_decap_8
XFILLER_22_339 VPWR VGND sg13g2_fill_2
X_1904_ net278 VPWR _0430_ VGND _0426_ _0429_ sg13g2_o21ai_1
X_2884_ net71 VGND VPWR _0105_ falutop.alu_data_in\[8\] clknet_5_21__leaf_clk sg13g2_dfrbpq_1
XFILLER_30_372 VPWR VGND sg13g2_decap_8
XFILLER_30_383 VPWR VGND sg13g2_fill_1
X_1835_ net335 net347 _0362_ VPWR VGND sg13g2_nor2b_1
X_1766_ _0294_ VPWR _0295_ VGND _0243_ _0245_ sg13g2_o21ai_1
X_2897__161 VPWR VGND net161 sg13g2_tiehi
X_1697_ _1017_ _1016_ _0942_ _0227_ VPWR VGND sg13g2_mux2_1
X_2318_ _0777_ _0776_ _0769_ _0778_ VPWR VGND sg13g2_a21o_1
Xheichips25_template_12 VPWR VGND uio_oe[7] sg13g2_tielo
XFILLER_39_940 VPWR VGND sg13g2_decap_8
Xheichips25_template_23 VPWR VGND uo_out[3] sg13g2_tielo
XFILLER_38_461 VPWR VGND sg13g2_fill_2
X_2249_ net334 _0717_ VPWR VGND sg13g2_inv_4
XFILLER_14_829 VPWR VGND sg13g2_decap_8
XFILLER_40_114 VPWR VGND sg13g2_decap_8
XFILLER_22_840 VPWR VGND sg13g2_decap_4
X_2841__171 VPWR VGND net171 sg13g2_tiehi
Xclkbuf_4_10_0_clk clknet_0_clk clknet_4_10_0_clk VPWR VGND sg13g2_buf_8
XFILLER_1_700 VPWR VGND sg13g2_decap_8
XFILLER_0_210 VPWR VGND sg13g2_decap_8
XFILLER_49_715 VPWR VGND sg13g2_fill_1
XFILLER_1_777 VPWR VGND sg13g2_decap_8
XFILLER_49_748 VPWR VGND sg13g2_decap_8
XFILLER_0_287 VPWR VGND sg13g2_decap_8
XFILLER_45_910 VPWR VGND sg13g2_decap_8
XFILLER_17_601 VPWR VGND sg13g2_decap_8
XFILLER_29_461 VPWR VGND sg13g2_decap_8
XFILLER_17_634 VPWR VGND sg13g2_decap_4
XFILLER_45_987 VPWR VGND sg13g2_decap_8
XFILLER_16_144 VPWR VGND sg13g2_decap_8
XFILLER_32_615 VPWR VGND sg13g2_decap_8
XFILLER_44_486 VPWR VGND sg13g2_decap_8
XFILLER_32_648 VPWR VGND sg13g2_fill_1
XFILLER_40_681 VPWR VGND sg13g2_fill_2
XFILLER_13_873 VPWR VGND sg13g2_decap_8
XFILLER_40_692 VPWR VGND sg13g2_decap_8
XFILLER_8_354 VPWR VGND sg13g2_decap_8
XFILLER_9_866 VPWR VGND sg13g2_decap_8
X_1620_ _1232_ _1230_ _0149_ _0151_ VPWR VGND sg13g2_a21o_1
X_1551_ _1252_ _1165_ _1250_ VPWR VGND sg13g2_xnor2_1
XFILLER_4_593 VPWR VGND sg13g2_decap_8
X_1482_ _1179_ _1183_ _1184_ VPWR VGND sg13g2_nor2_1
XFILLER_39_247 VPWR VGND sg13g2_fill_2
X_2103_ net510 net338 net284 _0106_ VPWR VGND sg13g2_mux2_1
XFILLER_48_770 VPWR VGND sg13g2_decap_8
XFILLER_47_280 VPWR VGND sg13g2_fill_1
X_2034_ VGND VPWR _0551_ _0555_ _0092_ _0556_ sg13g2_a21oi_1
XFILLER_35_453 VPWR VGND sg13g2_decap_8
XFILLER_36_976 VPWR VGND sg13g2_decap_8
XFILLER_22_147 VPWR VGND sg13g2_decap_4
XFILLER_22_158 VPWR VGND sg13g2_fill_1
XFILLER_31_670 VPWR VGND sg13g2_decap_8
X_2867_ net120 VGND VPWR net444 falutop.i2c_inst.result\[9\] clknet_5_25__leaf_clk
+ sg13g2_dfrbpq_1
X_1818_ _0344_ _0345_ _0087_ VPWR VGND sg13g2_nor2_1
X_2798_ net79 VGND VPWR net219 falutop.i2c_inst.op\[3\] clknet_5_30__leaf_clk sg13g2_dfrbpq_1
XFILLER_2_508 VPWR VGND sg13g2_decap_8
X_1749_ _0278_ net345 net348 VPWR VGND sg13g2_nand2_1
XFILLER_46_707 VPWR VGND sg13g2_decap_8
XFILLER_26_11 VPWR VGND sg13g2_decap_8
XFILLER_27_932 VPWR VGND sg13g2_decap_8
XFILLER_26_475 VPWR VGND sg13g2_decap_8
XFILLER_42_968 VPWR VGND sg13g2_decap_8
XFILLER_41_434 VPWR VGND sg13g2_decap_8
XFILLER_22_681 VPWR VGND sg13g2_fill_2
XFILLER_6_825 VPWR VGND sg13g2_decap_8
XFILLER_10_865 VPWR VGND sg13g2_decap_8
XFILLER_5_346 VPWR VGND sg13g2_decap_8
XFILLER_1_574 VPWR VGND sg13g2_decap_8
XFILLER_49_545 VPWR VGND sg13g2_decap_8
XFILLER_45_740 VPWR VGND sg13g2_decap_8
XFILLER_18_954 VPWR VGND sg13g2_decap_8
XFILLER_44_250 VPWR VGND sg13g2_decap_8
XFILLER_17_453 VPWR VGND sg13g2_fill_1
XFILLER_32_423 VPWR VGND sg13g2_decap_8
XFILLER_33_924 VPWR VGND sg13g2_decap_8
XFILLER_13_670 VPWR VGND sg13g2_fill_1
XFILLER_34_1023 VPWR VGND sg13g2_decap_4
X_2721_ net283 VPWR _1108_ VGND net363 net271 sg13g2_o21ai_1
XFILLER_9_663 VPWR VGND sg13g2_decap_8
X_2652_ _1010_ _1027_ _1036_ _1040_ _1041_ VPWR VGND sg13g2_nor4_1
X_2583_ _0972_ net347 net318 VPWR VGND sg13g2_nand2b_1
X_1603_ _1301_ _1302_ _1303_ VPWR VGND sg13g2_nor2b_1
X_1534_ net355 net330 net271 _1235_ VPWR VGND sg13g2_mux2_1
XFILLER_4_390 VPWR VGND sg13g2_decap_8
X_1465_ VGND VPWR net309 _0924_ _1167_ _1166_ sg13g2_a21oi_1
XFILLER_41_1005 VPWR VGND sg13g2_decap_8
X_2017_ _0540_ _0538_ _0539_ VPWR VGND sg13g2_nand2_1
XFILLER_36_740 VPWR VGND sg13g2_decap_8
XFILLER_35_250 VPWR VGND sg13g2_decap_8
XFILLER_35_283 VPWR VGND sg13g2_decap_8
XFILLER_23_456 VPWR VGND sg13g2_decap_8
XFILLER_24_968 VPWR VGND sg13g2_decap_8
X_2919_ net121 VGND VPWR _0140_ falutop.i2c_inst.data_in\[12\] clknet_5_13__leaf_clk
+ sg13g2_dfrbpq_1
X_2903__149 VPWR VGND net149 sg13g2_tiehi
XFILLER_12_68 VPWR VGND sg13g2_decap_8
XFILLER_3_806 VPWR VGND sg13g2_decap_8
XFILLER_2_305 VPWR VGND sg13g2_decap_8
Xhold162 falutop.i2c_inst.result\[5\] VPWR VGND net463 sg13g2_dlygate4sd3_1
Xhold140 falutop.i2c_inst.counter\[0\] VPWR VGND net441 sg13g2_dlygate4sd3_1
Xhold151 _0090_ VPWR VGND net452 sg13g2_dlygate4sd3_1
Xhold195 falutop.i2c_inst.sda_o VPWR VGND net496 sg13g2_dlygate4sd3_1
Xhold184 falutop.div_inst.b1\[5\] VPWR VGND net485 sg13g2_dlygate4sd3_1
Xhold173 _0079_ VPWR VGND net474 sg13g2_dlygate4sd3_1
XFILLER_46_548 VPWR VGND sg13g2_fill_2
XFILLER_37_65 VPWR VGND sg13g2_decap_4
XFILLER_18_228 VPWR VGND sg13g2_fill_1
XFILLER_27_740 VPWR VGND sg13g2_fill_2
XFILLER_42_721 VPWR VGND sg13g2_decap_8
XFILLER_26_250 VPWR VGND sg13g2_decap_8
XFILLER_41_231 VPWR VGND sg13g2_decap_8
XFILLER_14_445 VPWR VGND sg13g2_fill_2
XFILLER_15_957 VPWR VGND sg13g2_decap_8
XFILLER_41_253 VPWR VGND sg13g2_decap_8
XFILLER_14_467 VPWR VGND sg13g2_decap_8
XFILLER_30_938 VPWR VGND sg13g2_decap_8
XFILLER_41_286 VPWR VGND sg13g2_decap_4
XFILLER_10_662 VPWR VGND sg13g2_decap_4
XFILLER_6_622 VPWR VGND sg13g2_decap_8
XFILLER_5_110 VPWR VGND sg13g2_fill_1
XFILLER_6_699 VPWR VGND sg13g2_decap_8
XFILLER_5_187 VPWR VGND sg13g2_decap_8
XFILLER_2_872 VPWR VGND sg13g2_decap_8
XFILLER_1_371 VPWR VGND sg13g2_decap_8
XFILLER_38_7 VPWR VGND sg13g2_decap_4
XFILLER_49_342 VPWR VGND sg13g2_fill_1
XFILLER_49_331 VPWR VGND sg13g2_decap_8
XFILLER_49_375 VPWR VGND sg13g2_decap_8
XFILLER_33_710 VPWR VGND sg13g2_fill_2
XFILLER_45_592 VPWR VGND sg13g2_decap_8
XFILLER_33_732 VPWR VGND sg13g2_decap_8
XFILLER_14_990 VPWR VGND sg13g2_decap_8
X_2704_ _1006_ _1091_ _0966_ _1092_ VPWR VGND sg13g2_nand3_1
X_2635_ VGND VPWR _0719_ net327 _1024_ net319 sg13g2_a21oi_1
X_2566_ _0955_ _0923_ _0954_ VPWR VGND sg13g2_xnor2_1
X_2497_ VGND VPWR _0707_ net302 _0064_ _0900_ sg13g2_a21oi_1
X_1517_ VGND VPWR _1218_ _1217_ _1216_ sg13g2_or2_1
XFILLER_28_548 VPWR VGND sg13g2_fill_2
XFILLER_28_559 VPWR VGND sg13g2_fill_2
XFILLER_24_732 VPWR VGND sg13g2_decap_8
XFILLER_12_927 VPWR VGND sg13g2_decap_8
XFILLER_11_459 VPWR VGND sg13g2_decap_8
XFILLER_23_89 VPWR VGND sg13g2_decap_8
XFILLER_3_603 VPWR VGND sg13g2_decap_8
XFILLER_2_102 VPWR VGND sg13g2_decap_8
XFILLER_3_4 VPWR VGND sg13g2_decap_8
XFILLER_2_179 VPWR VGND sg13g2_decap_8
XFILLER_48_42 VPWR VGND sg13g2_decap_8
XFILLER_47_868 VPWR VGND sg13g2_decap_8
XFILLER_0_49 VPWR VGND sg13g2_decap_8
XFILLER_27_581 VPWR VGND sg13g2_decap_4
XFILLER_34_518 VPWR VGND sg13g2_fill_2
XFILLER_9_25 VPWR VGND sg13g2_decap_8
XFILLER_30_779 VPWR VGND sg13g2_decap_8
XFILLER_31_1004 VPWR VGND sg13g2_decap_8
XFILLER_7_920 VPWR VGND sg13g2_decap_8
XFILLER_11_993 VPWR VGND sg13g2_decap_8
XFILLER_6_430 VPWR VGND sg13g2_fill_1
XFILLER_7_997 VPWR VGND sg13g2_decap_8
XFILLER_6_496 VPWR VGND sg13g2_decap_8
X_2420_ net175 net303 _0861_ VPWR VGND sg13g2_nor2_1
XFILLER_9_1027 VPWR VGND sg13g2_fill_2
X_2351_ _0806_ net266 net277 VPWR VGND sg13g2_nand2_1
X_2282_ net199 net275 _0748_ VPWR VGND sg13g2_nor2_1
XFILLER_49_183 VPWR VGND sg13g2_decap_8
XFILLER_37_323 VPWR VGND sg13g2_decap_8
XFILLER_25_507 VPWR VGND sg13g2_decap_8
XFILLER_46_890 VPWR VGND sg13g2_decap_8
XFILLER_21_702 VPWR VGND sg13g2_fill_2
XFILLER_20_201 VPWR VGND sg13g2_fill_2
X_1997_ _0350_ VPWR _0520_ VGND _1307_ _0488_ sg13g2_o21ai_1
XFILLER_20_245 VPWR VGND sg13g2_decap_8
XFILLER_47_1022 VPWR VGND sg13g2_decap_8
X_2618_ _0921_ VPWR _1007_ VGND _1005_ _1006_ sg13g2_o21ai_1
X_2549_ net315 net347 _0938_ VPWR VGND sg13g2_nor2_2
XFILLER_18_78 VPWR VGND sg13g2_fill_1
X_2835__30 VPWR VGND net30 sg13g2_tiehi
XFILLER_28_389 VPWR VGND sg13g2_decap_8
XFILLER_12_713 VPWR VGND sg13g2_fill_2
XFILLER_11_223 VPWR VGND sg13g2_fill_2
XFILLER_12_746 VPWR VGND sg13g2_decap_8
XFILLER_11_234 VPWR VGND sg13g2_fill_2
XFILLER_4_901 VPWR VGND sg13g2_decap_8
XFILLER_3_400 VPWR VGND sg13g2_decap_8
XFILLER_4_978 VPWR VGND sg13g2_decap_8
XFILLER_3_477 VPWR VGND sg13g2_decap_8
XFILLER_47_621 VPWR VGND sg13g2_decap_8
XFILLER_19_323 VPWR VGND sg13g2_decap_8
Xfanout291 net292 net291 VPWR VGND sg13g2_buf_8
Xfanout280 _1018_ net280 VPWR VGND sg13g2_buf_8
XFILLER_47_654 VPWR VGND sg13g2_fill_2
XFILLER_46_131 VPWR VGND sg13g2_fill_1
XFILLER_47_687 VPWR VGND sg13g2_fill_1
XFILLER_46_197 VPWR VGND sg13g2_decap_8
XFILLER_28_890 VPWR VGND sg13g2_fill_2
XFILLER_43_871 VPWR VGND sg13g2_decap_8
XFILLER_15_540 VPWR VGND sg13g2_decap_8
X_1920_ _0445_ _0262_ _0444_ VPWR VGND sg13g2_xnor2_1
XFILLER_42_370 VPWR VGND sg13g2_decap_8
X_1851_ _0376_ _0375_ _0378_ VPWR VGND sg13g2_xor2_1
XFILLER_30_565 VPWR VGND sg13g2_decap_8
X_1782_ _0310_ _0305_ _0308_ VPWR VGND sg13g2_xnor2_1
XFILLER_11_790 VPWR VGND sg13g2_decap_8
XFILLER_7_794 VPWR VGND sg13g2_decap_8
X_2403_ VGND VPWR net1 _0826_ _0848_ _0847_ sg13g2_a21oi_1
X_2334_ _0792_ VPWR _0793_ VGND net216 net270 sg13g2_o21ai_1
XFILLER_27_0 VPWR VGND sg13g2_decap_8
XFILLER_29_109 VPWR VGND sg13g2_decap_4
X_2265_ net242 net450 net412 net268 _0733_ VPWR VGND sg13g2_nor4_1
X_2196_ _0675_ _0709_ net437 VPWR VGND sg13g2_nand2_2
XFILLER_38_643 VPWR VGND sg13g2_decap_8
XFILLER_1_70 VPWR VGND sg13g2_decap_8
XFILLER_25_304 VPWR VGND sg13g2_decap_8
XFILLER_26_827 VPWR VGND sg13g2_decap_4
XFILLER_40_307 VPWR VGND sg13g2_decap_8
XFILLER_21_510 VPWR VGND sg13g2_fill_1
XFILLER_21_532 VPWR VGND sg13g2_decap_8
XFILLER_1_959 VPWR VGND sg13g2_decap_8
Xhold22 _0001_ VPWR VGND net196 sg13g2_dlygate4sd3_1
XFILLER_0_469 VPWR VGND sg13g2_decap_8
Xhold11 _0119_ VPWR VGND net185 sg13g2_dlygate4sd3_1
Xhold44 falutop.i2c_inst.data_in\[19\] VPWR VGND net218 sg13g2_dlygate4sd3_1
Xhold33 falutop.data_in\[0\] VPWR VGND net207 sg13g2_dlygate4sd3_1
Xhold55 _0014_ VPWR VGND net229 sg13g2_dlygate4sd3_1
Xhold66 falutop.i2c_inst.data_in\[11\] VPWR VGND net240 sg13g2_dlygate4sd3_1
Xhold77 _0047_ VPWR VGND net251 sg13g2_dlygate4sd3_1
Xhold99 falutop.div_inst.acc\[8\] VPWR VGND net400 sg13g2_dlygate4sd3_1
Xhold88 falutop.div_inst.acc\[5\] VPWR VGND net262 sg13g2_dlygate4sd3_1
XFILLER_29_99 VPWR VGND sg13g2_decap_4
XFILLER_29_632 VPWR VGND sg13g2_decap_8
XFILLER_29_665 VPWR VGND sg13g2_decap_4
XFILLER_28_142 VPWR VGND sg13g2_decap_8
XFILLER_28_153 VPWR VGND sg13g2_fill_2
XFILLER_29_687 VPWR VGND sg13g2_decap_8
XFILLER_45_54 VPWR VGND sg13g2_decap_8
XFILLER_28_197 VPWR VGND sg13g2_decap_8
XFILLER_25_871 VPWR VGND sg13g2_decap_8
XFILLER_40_863 VPWR VGND sg13g2_decap_8
XFILLER_12_587 VPWR VGND sg13g2_decap_8
XFILLER_8_558 VPWR VGND sg13g2_decap_8
XFILLER_4_775 VPWR VGND sg13g2_decap_8
XFILLER_39_418 VPWR VGND sg13g2_fill_2
XFILLER_48_952 VPWR VGND sg13g2_decap_8
X_2050_ _0570_ VPWR _0572_ VGND _0544_ _0557_ sg13g2_o21ai_1
XFILLER_47_462 VPWR VGND sg13g2_decap_4
XFILLER_15_381 VPWR VGND sg13g2_fill_1
XFILLER_16_882 VPWR VGND sg13g2_decap_8
XFILLER_15_392 VPWR VGND sg13g2_decap_8
X_1903_ _0339_ VPWR _0429_ VGND _0427_ _0428_ sg13g2_o21ai_1
X_2883_ net73 VGND VPWR net518 falutop.alu_data_in\[7\] clknet_5_29__leaf_clk sg13g2_dfrbpq_1
XFILLER_31_885 VPWR VGND sg13g2_decap_8
X_1834_ _0361_ net320 net359 VPWR VGND sg13g2_nand2_1
X_1765_ _0293_ VPWR _0294_ VGND _0291_ _0292_ sg13g2_o21ai_1
XFILLER_7_591 VPWR VGND sg13g2_decap_8
X_1696_ _0944_ _0225_ _0226_ VPWR VGND sg13g2_nor2_1
XFILLER_44_1014 VPWR VGND sg13g2_decap_8
X_2317_ _0777_ falutop.div_inst.b1\[3\] falutop.div_inst.acc\[3\] VPWR VGND sg13g2_xnor2_1
Xheichips25_template_24 VPWR VGND uo_out[4] sg13g2_tielo
X_2248_ net343 _0716_ VPWR VGND sg13g2_inv_4
Xheichips25_template_13 VPWR VGND uio_out[0] sg13g2_tielo
XFILLER_39_996 VPWR VGND sg13g2_decap_8
X_2179_ _0835_ _0653_ _0663_ VPWR VGND sg13g2_nor2_1
XFILLER_38_484 VPWR VGND sg13g2_decap_8
XFILLER_25_101 VPWR VGND sg13g2_decap_8
XFILLER_25_112 VPWR VGND sg13g2_decap_8
XFILLER_26_679 VPWR VGND sg13g2_decap_8
XFILLER_41_638 VPWR VGND sg13g2_decap_8
XFILLER_13_318 VPWR VGND sg13g2_fill_1
XFILLER_25_178 VPWR VGND sg13g2_decap_4
X_2805__66 VPWR VGND net66 sg13g2_tiehi
XFILLER_40_159 VPWR VGND sg13g2_decap_4
XFILLER_21_340 VPWR VGND sg13g2_fill_1
XFILLER_31_67 VPWR VGND sg13g2_decap_8
XFILLER_5_539 VPWR VGND sg13g2_decap_8
XFILLER_1_756 VPWR VGND sg13g2_decap_8
XFILLER_49_727 VPWR VGND sg13g2_decap_8
XFILLER_0_266 VPWR VGND sg13g2_decap_8
XFILLER_29_440 VPWR VGND sg13g2_decap_8
XFILLER_16_101 VPWR VGND sg13g2_fill_2
XFILLER_16_123 VPWR VGND sg13g2_decap_8
XFILLER_45_966 VPWR VGND sg13g2_decap_8
XFILLER_17_657 VPWR VGND sg13g2_decap_4
XFILLER_31_104 VPWR VGND sg13g2_fill_2
XFILLER_32_627 VPWR VGND sg13g2_decap_8
XFILLER_13_852 VPWR VGND sg13g2_decap_8
XFILLER_31_126 VPWR VGND sg13g2_decap_4
XFILLER_40_660 VPWR VGND sg13g2_decap_8
XFILLER_9_845 VPWR VGND sg13g2_decap_8
XFILLER_8_333 VPWR VGND sg13g2_fill_1
XFILLER_8_322 VPWR VGND sg13g2_decap_8
XFILLER_12_373 VPWR VGND sg13g2_decap_8
XFILLER_8_399 VPWR VGND sg13g2_decap_8
X_1550_ _1165_ _1250_ _1251_ VPWR VGND sg13g2_nor2b_1
XFILLER_4_572 VPWR VGND sg13g2_decap_8
X_1481_ _1016_ _1017_ _0924_ _1183_ VPWR VGND sg13g2_mux2_1
XFILLER_39_237 VPWR VGND sg13g2_decap_4
X_2102_ VGND VPWR _0716_ net284 _0105_ _0611_ sg13g2_a21oi_1
XFILLER_35_432 VPWR VGND sg13g2_decap_8
X_2033_ net392 VPWR _0556_ VGND net471 net294 sg13g2_o21ai_1
XFILLER_36_955 VPWR VGND sg13g2_decap_8
XFILLER_35_498 VPWR VGND sg13g2_decap_8
X_2866_ net122 VGND VPWR net468 falutop.i2c_inst.result\[8\] clknet_5_22__leaf_clk
+ sg13g2_dfrbpq_1
X_1817_ net392 VPWR _0345_ VGND net467 net294 sg13g2_o21ai_1
X_2797_ net80 VGND VPWR net221 falutop.i2c_inst.op\[2\] clknet_5_30__leaf_clk sg13g2_dfrbpq_1
XFILLER_7_91 VPWR VGND sg13g2_decap_8
X_1748_ _0277_ net329 net359 VPWR VGND sg13g2_nand2_1
X_1679_ _0209_ _0195_ _0208_ VPWR VGND sg13g2_xnor2_1
XFILLER_27_911 VPWR VGND sg13g2_decap_8
XFILLER_38_281 VPWR VGND sg13g2_decap_8
XFILLER_14_605 VPWR VGND sg13g2_fill_2
XFILLER_26_454 VPWR VGND sg13g2_decap_8
XFILLER_27_988 VPWR VGND sg13g2_decap_8
XFILLER_42_947 VPWR VGND sg13g2_decap_8
XFILLER_14_627 VPWR VGND sg13g2_decap_8
XFILLER_26_498 VPWR VGND sg13g2_fill_1
XFILLER_13_137 VPWR VGND sg13g2_fill_2
XFILLER_13_148 VPWR VGND sg13g2_decap_8
XFILLER_41_479 VPWR VGND sg13g2_decap_8
XFILLER_42_77 VPWR VGND sg13g2_decap_8
XFILLER_42_66 VPWR VGND sg13g2_fill_1
XFILLER_10_844 VPWR VGND sg13g2_decap_8
XFILLER_6_804 VPWR VGND sg13g2_decap_8
XFILLER_1_553 VPWR VGND sg13g2_decap_8
XFILLER_49_524 VPWR VGND sg13g2_decap_8
XFILLER_18_933 VPWR VGND sg13g2_decap_8
XFILLER_29_281 VPWR VGND sg13g2_decap_4
XFILLER_33_903 VPWR VGND sg13g2_decap_8
XFILLER_17_487 VPWR VGND sg13g2_decap_8
XFILLER_32_402 VPWR VGND sg13g2_decap_8
XFILLER_44_284 VPWR VGND sg13g2_fill_2
XFILLER_34_1002 VPWR VGND sg13g2_decap_8
XFILLER_41_991 VPWR VGND sg13g2_decap_8
XFILLER_8_130 VPWR VGND sg13g2_decap_8
XFILLER_12_181 VPWR VGND sg13g2_decap_8
X_2720_ _0960_ VPWR _1107_ VGND _1052_ _1057_ sg13g2_o21ai_1
XFILLER_13_693 VPWR VGND sg13g2_fill_2
X_2651_ _1039_ VPWR _1040_ VGND _0923_ _1015_ sg13g2_o21ai_1
X_1602_ _1254_ VPWR _1302_ VGND _1299_ _1300_ sg13g2_o21ai_1
X_2582_ VGND VPWR _0962_ _0971_ _0970_ _0919_ sg13g2_a21oi_2
X_1533_ net281 _1233_ _1234_ VPWR VGND sg13g2_and2_1
X_1464_ _1166_ net358 net344 net367 net332 VPWR VGND sg13g2_a22oi_1
XFILLER_41_1028 VPWR VGND sg13g2_fill_1
XFILLER_27_218 VPWR VGND sg13g2_decap_8
X_2016_ _0504_ VPWR _0539_ VGND _0481_ _0502_ sg13g2_o21ai_1
XFILLER_24_947 VPWR VGND sg13g2_decap_8
XFILLER_36_785 VPWR VGND sg13g2_decap_4
XFILLER_23_435 VPWR VGND sg13g2_decap_8
XFILLER_23_479 VPWR VGND sg13g2_fill_1
X_2918_ net129 VGND VPWR _0139_ falutop.i2c_inst.data_in\[11\] clknet_5_26__leaf_clk
+ sg13g2_dfrbpq_1
X_2849_ net156 VGND VPWR net204 falutop.div_inst.val\[7\] clknet_5_5__leaf_clk sg13g2_dfrbpq_2
XFILLER_12_58 VPWR VGND sg13g2_decap_4
Xhold141 falutop.i2c_inst.counter\[3\] VPWR VGND net442 sg13g2_dlygate4sd3_1
Xhold130 _0042_ VPWR VGND net431 sg13g2_dlygate4sd3_1
Xhold152 falutop.alu_data_in\[4\] VPWR VGND net453 sg13g2_dlygate4sd3_1
Xhold185 falutop.i2c_inst.result\[2\] VPWR VGND net486 sg13g2_dlygate4sd3_1
Xhold163 _0084_ VPWR VGND net464 sg13g2_dlygate4sd3_1
Xhold174 falutop.i2c_inst.result\[7\] VPWR VGND net475 sg13g2_dlygate4sd3_1
Xhold196 falutop.alu_data_in\[1\] VPWR VGND net497 sg13g2_dlygate4sd3_1
XFILLER_37_11 VPWR VGND sg13g2_fill_1
XFILLER_19_708 VPWR VGND sg13g2_decap_8
XFILLER_46_527 VPWR VGND sg13g2_decap_8
XFILLER_37_44 VPWR VGND sg13g2_decap_8
XFILLER_42_700 VPWR VGND sg13g2_decap_8
XFILLER_15_936 VPWR VGND sg13g2_decap_8
XFILLER_27_785 VPWR VGND sg13g2_decap_8
XFILLER_42_744 VPWR VGND sg13g2_fill_1
XFILLER_14_424 VPWR VGND sg13g2_decap_8
XFILLER_42_788 VPWR VGND sg13g2_decap_8
XFILLER_30_917 VPWR VGND sg13g2_decap_8
XFILLER_6_601 VPWR VGND sg13g2_decap_8
XFILLER_22_490 VPWR VGND sg13g2_decap_8
XFILLER_6_678 VPWR VGND sg13g2_decap_8
XFILLER_5_166 VPWR VGND sg13g2_fill_2
XFILLER_2_851 VPWR VGND sg13g2_decap_8
XFILLER_1_350 VPWR VGND sg13g2_decap_8
XFILLER_49_310 VPWR VGND sg13g2_decap_8
XFILLER_49_354 VPWR VGND sg13g2_decap_8
XFILLER_49_398 VPWR VGND sg13g2_fill_2
XFILLER_18_730 VPWR VGND sg13g2_fill_1
XFILLER_17_273 VPWR VGND sg13g2_fill_1
XFILLER_18_785 VPWR VGND sg13g2_decap_4
XFILLER_21_939 VPWR VGND sg13g2_decap_8
XFILLER_20_416 VPWR VGND sg13g2_decap_8
X_2703_ _0933_ net343 _1091_ VPWR VGND net368 sg13g2_nand3b_1
X_2634_ VPWR _1023_ _1022_ VGND sg13g2_inv_1
X_2565_ _0952_ _0925_ _0954_ VPWR VGND sg13g2_xor2_1
X_1516_ VGND VPWR net340 net317 _1217_ net354 sg13g2_a21oi_1
X_2496_ net389 VPWR _0900_ VGND falutop.div_inst.val\[1\] net301 sg13g2_o21ai_1
XFILLER_4_81 VPWR VGND sg13g2_decap_8
XFILLER_23_221 VPWR VGND sg13g2_decap_8
XFILLER_23_232 VPWR VGND sg13g2_fill_1
XFILLER_24_755 VPWR VGND sg13g2_fill_1
XFILLER_12_906 VPWR VGND sg13g2_decap_8
XFILLER_24_777 VPWR VGND sg13g2_fill_1
XFILLER_23_287 VPWR VGND sg13g2_fill_2
XFILLER_7_409 VPWR VGND sg13g2_decap_8
XFILLER_3_659 VPWR VGND sg13g2_decap_8
XFILLER_2_158 VPWR VGND sg13g2_decap_8
XFILLER_48_21 VPWR VGND sg13g2_decap_8
XFILLER_19_505 VPWR VGND sg13g2_fill_1
XFILLER_47_847 VPWR VGND sg13g2_decap_8
XFILLER_0_28 VPWR VGND sg13g2_decap_8
XFILLER_46_379 VPWR VGND sg13g2_decap_4
XFILLER_27_571 VPWR VGND sg13g2_fill_2
XFILLER_14_221 VPWR VGND sg13g2_fill_2
XFILLER_15_722 VPWR VGND sg13g2_decap_8
XFILLER_27_593 VPWR VGND sg13g2_fill_1
XFILLER_30_703 VPWR VGND sg13g2_decap_4
XFILLER_30_747 VPWR VGND sg13g2_decap_4
XFILLER_30_758 VPWR VGND sg13g2_decap_8
XFILLER_10_460 VPWR VGND sg13g2_decap_8
XFILLER_11_972 VPWR VGND sg13g2_decap_8
XFILLER_7_976 VPWR VGND sg13g2_decap_8
XFILLER_6_475 VPWR VGND sg13g2_decap_8
XFILLER_9_1006 VPWR VGND sg13g2_decap_8
X_2350_ _0802_ VPWR _0012_ VGND _0731_ _0805_ sg13g2_o21ai_1
X_2281_ VGND VPWR net376 net182 _0747_ _0746_ sg13g2_a21oi_1
XFILLER_49_162 VPWR VGND sg13g2_decap_8
XFILLER_37_379 VPWR VGND sg13g2_decap_4
XFILLER_18_571 VPWR VGND sg13g2_fill_1
XFILLER_18_582 VPWR VGND sg13g2_fill_1
XFILLER_33_563 VPWR VGND sg13g2_decap_8
XFILLER_20_224 VPWR VGND sg13g2_decap_8
XFILLER_21_747 VPWR VGND sg13g2_decap_8
XFILLER_33_596 VPWR VGND sg13g2_fill_2
X_1996_ VGND VPWR _0484_ _0501_ _0519_ _0499_ sg13g2_a21oi_1
XFILLER_47_1001 VPWR VGND sg13g2_decap_8
X_2617_ falutop.alu_inst.op\[2\] net369 _1000_ _1006_ VPWR VGND sg13g2_nor3_2
X_2548_ _0935_ _0936_ _0937_ VPWR VGND sg13g2_nor2_2
X_2479_ net259 _0891_ _0895_ VPWR VGND sg13g2_nor2_1
XFILLER_28_302 VPWR VGND sg13g2_decap_8
XFILLER_44_839 VPWR VGND sg13g2_decap_8
XFILLER_11_213 VPWR VGND sg13g2_fill_1
XFILLER_34_56 VPWR VGND sg13g2_fill_1
XFILLER_11_246 VPWR VGND sg13g2_decap_4
XFILLER_7_239 VPWR VGND sg13g2_decap_8
Xclkload0 VPWR clkload0/Y clknet_5_3__leaf_clk VGND sg13g2_inv_1
XFILLER_4_957 VPWR VGND sg13g2_decap_8
Xclkbuf_5_29__f_clk clknet_4_14_0_clk clknet_5_29__leaf_clk VPWR VGND sg13g2_buf_8
XFILLER_3_456 VPWR VGND sg13g2_decap_8
Xfanout292 _0863_ net292 VPWR VGND sg13g2_buf_8
Xfanout270 _0787_ net270 VPWR VGND sg13g2_buf_8
XFILLER_19_302 VPWR VGND sg13g2_decap_8
X_2851__152 VPWR VGND net152 sg13g2_tiehi
Xfanout281 _1001_ net281 VPWR VGND sg13g2_buf_8
XFILLER_34_305 VPWR VGND sg13g2_decap_8
XFILLER_34_316 VPWR VGND sg13g2_fill_2
XFILLER_35_817 VPWR VGND sg13g2_decap_8
X_2826__42 VPWR VGND net42 sg13g2_tiehi
XFILLER_43_850 VPWR VGND sg13g2_decap_8
XFILLER_27_390 VPWR VGND sg13g2_fill_1
XFILLER_15_585 VPWR VGND sg13g2_fill_1
X_1850_ _0375_ _0376_ _0377_ VPWR VGND sg13g2_nor2_1
XFILLER_30_544 VPWR VGND sg13g2_decap_8
X_1781_ _0309_ _0305_ _0308_ VPWR VGND sg13g2_nand2_1
XFILLER_7_773 VPWR VGND sg13g2_decap_8
X_2402_ _0826_ _0845_ _0846_ _0847_ VPWR VGND sg13g2_nor3_1
X_2333_ _0792_ net270 _0791_ VPWR VGND sg13g2_nand2_1
X_2264_ net425 net414 net479 net222 _0732_ VPWR VGND sg13g2_nor4_1
X_2195_ net434 falutop.i2c_inst.counter\[3\] _0674_ VPWR VGND sg13g2_nor2b_2
XFILLER_37_132 VPWR VGND sg13g2_fill_1
XFILLER_37_121 VPWR VGND sg13g2_decap_8
XFILLER_26_806 VPWR VGND sg13g2_fill_1
XFILLER_38_677 VPWR VGND sg13g2_decap_4
X_2817__53 VPWR VGND net53 sg13g2_tiehi
X_2832__34 VPWR VGND net34 sg13g2_tiehi
XFILLER_34_883 VPWR VGND sg13g2_decap_8
XFILLER_14_1011 VPWR VGND sg13g2_decap_8
X_1979_ _0502_ _0481_ _0503_ VPWR VGND sg13g2_xor2_1
XFILLER_1_938 VPWR VGND sg13g2_decap_8
XFILLER_49_909 VPWR VGND sg13g2_decap_8
Xhold23 falutop.i2c_inst.data_in\[0\] VPWR VGND net197 sg13g2_dlygate4sd3_1
XFILLER_0_448 VPWR VGND sg13g2_decap_8
Xhold12 falutop.div_inst.quo\[4\] VPWR VGND net186 sg13g2_dlygate4sd3_1
Xhold45 _0019_ VPWR VGND net219 sg13g2_dlygate4sd3_1
Xhold34 falutop.div_inst.quo\[1\] VPWR VGND net208 sg13g2_dlygate4sd3_1
Xhold56 falutop.div_inst.acc\[4\] VPWR VGND net230 sg13g2_dlygate4sd3_1
XFILLER_29_78 VPWR VGND sg13g2_decap_8
Xhold67 _0039_ VPWR VGND net241 sg13g2_dlygate4sd3_1
Xhold78 falutop.i2c_inst.data_in\[4\] VPWR VGND net252 sg13g2_dlygate4sd3_1
Xhold89 _0012_ VPWR VGND net263 sg13g2_dlygate4sd3_1
XFILLER_28_121 VPWR VGND sg13g2_decap_8
XFILLER_17_839 VPWR VGND sg13g2_decap_8
XFILLER_28_165 VPWR VGND sg13g2_decap_4
XFILLER_45_33 VPWR VGND sg13g2_decap_8
XFILLER_44_658 VPWR VGND sg13g2_decap_8
XFILLER_43_102 VPWR VGND sg13g2_fill_2
XFILLER_16_316 VPWR VGND sg13g2_fill_1
XFILLER_16_349 VPWR VGND sg13g2_decap_8
XFILLER_45_99 VPWR VGND sg13g2_fill_2
XFILLER_25_850 VPWR VGND sg13g2_decap_8
XFILLER_8_537 VPWR VGND sg13g2_decap_8
XFILLER_12_566 VPWR VGND sg13g2_fill_1
XFILLER_4_754 VPWR VGND sg13g2_decap_8
XFILLER_3_242 VPWR VGND sg13g2_decap_8
XFILLER_10_80 VPWR VGND sg13g2_decap_8
XFILLER_48_931 VPWR VGND sg13g2_decap_8
XFILLER_19_110 VPWR VGND sg13g2_fill_2
XFILLER_47_452 VPWR VGND sg13g2_decap_4
XFILLER_35_603 VPWR VGND sg13g2_decap_8
XFILLER_16_861 VPWR VGND sg13g2_decap_8
XFILLER_23_809 VPWR VGND sg13g2_decap_8
XFILLER_34_135 VPWR VGND sg13g2_decap_8
XFILLER_35_658 VPWR VGND sg13g2_fill_2
XFILLER_22_308 VPWR VGND sg13g2_decap_8
X_2814__56 VPWR VGND net56 sg13g2_tiehi
XFILLER_42_190 VPWR VGND sg13g2_fill_1
XFILLER_31_864 VPWR VGND sg13g2_decap_8
X_1902_ net282 VPWR _0428_ VGND net363 _0976_ sg13g2_o21ai_1
X_2882_ net75 VGND VPWR net522 falutop.alu_data_in\[6\] clknet_5_28__leaf_clk sg13g2_dfrbpq_2
X_1833_ VGND VPWR _0272_ _0323_ _0360_ _0322_ sg13g2_a21oi_1
X_1764_ VGND VPWR _0291_ _0292_ _0293_ _1019_ sg13g2_a21oi_1
XFILLER_7_570 VPWR VGND sg13g2_decap_8
X_1695_ VGND VPWR _0943_ _1014_ _0225_ _1012_ sg13g2_a21oi_1
Xclkbuf_5_12__f_clk clknet_4_6_0_clk clknet_5_12__leaf_clk VPWR VGND sg13g2_buf_8
X_2316_ _0770_ VPWR _0776_ VGND _0774_ _0775_ sg13g2_o21ai_1
XFILLER_38_430 VPWR VGND sg13g2_decap_4
Xheichips25_template_25 VPWR VGND uo_out[5] sg13g2_tielo
Xheichips25_template_14 VPWR VGND uio_out[1] sg13g2_tielo
X_2247_ VPWR _0715_ net228 VGND sg13g2_inv_1
XFILLER_39_975 VPWR VGND sg13g2_decap_8
XFILLER_38_463 VPWR VGND sg13g2_fill_1
X_2178_ VGND VPWR net382 _0661_ _0130_ _0662_ sg13g2_a21oi_1
XFILLER_26_625 VPWR VGND sg13g2_decap_8
XFILLER_26_647 VPWR VGND sg13g2_decap_8
XFILLER_41_617 VPWR VGND sg13g2_decap_8
XFILLER_40_149 VPWR VGND sg13g2_fill_1
XFILLER_15_58 VPWR VGND sg13g2_decap_8
XFILLER_21_330 VPWR VGND sg13g2_fill_1
XFILLER_33_190 VPWR VGND sg13g2_fill_1
XFILLER_22_864 VPWR VGND sg13g2_decap_8
XFILLER_22_886 VPWR VGND sg13g2_decap_8
XFILLER_31_35 VPWR VGND sg13g2_decap_4
XFILLER_5_518 VPWR VGND sg13g2_decap_8
XFILLER_1_735 VPWR VGND sg13g2_decap_8
XFILLER_49_706 VPWR VGND sg13g2_decap_8
XFILLER_0_245 VPWR VGND sg13g2_decap_8
XFILLER_29_430 VPWR VGND sg13g2_fill_1
XFILLER_45_945 VPWR VGND sg13g2_decap_8
XFILLER_29_496 VPWR VGND sg13g2_decap_8
XFILLER_44_466 VPWR VGND sg13g2_decap_8
XFILLER_13_831 VPWR VGND sg13g2_decap_8
XFILLER_9_824 VPWR VGND sg13g2_decap_8
XFILLER_40_683 VPWR VGND sg13g2_fill_1
X_2811__59 VPWR VGND net59 sg13g2_tiehi
XFILLER_4_551 VPWR VGND sg13g2_decap_8
X_1480_ _0986_ _1004_ net369 _1182_ VPWR VGND _1032_ sg13g2_nand4_1
X_2101_ net254 net284 _0611_ VPWR VGND sg13g2_nor2_1
XFILLER_11_4 VPWR VGND sg13g2_decap_8
X_2032_ VGND VPWR net305 _0554_ _0555_ net296 sg13g2_a21oi_1
XFILLER_35_411 VPWR VGND sg13g2_decap_8
XFILLER_36_934 VPWR VGND sg13g2_decap_8
XFILLER_23_617 VPWR VGND sg13g2_decap_4
X_2865_ net124 VGND VPWR net476 falutop.i2c_inst.result\[7\] clknet_5_23__leaf_clk
+ sg13g2_dfrbpq_1
XFILLER_30_160 VPWR VGND sg13g2_decap_8
XFILLER_11_1014 VPWR VGND sg13g2_decap_8
X_1816_ VPWR VGND _0343_ net296 net278 falutop.div_inst.rem\[0\] _0344_ net304 sg13g2_a221oi_1
X_2796_ net81 VGND VPWR net265 falutop.i2c_inst.op\[1\] clknet_5_29__leaf_clk sg13g2_dfrbpq_1
XFILLER_7_70 VPWR VGND sg13g2_decap_8
X_1747_ _0276_ _0271_ _0275_ VPWR VGND sg13g2_xnor2_1
X_1678_ _0208_ _1289_ _0206_ VPWR VGND sg13g2_xnor2_1
XFILLER_39_772 VPWR VGND sg13g2_decap_8
XFILLER_38_271 VPWR VGND sg13g2_fill_2
XFILLER_38_260 VPWR VGND sg13g2_decap_4
XFILLER_26_400 VPWR VGND sg13g2_decap_8
XFILLER_26_433 VPWR VGND sg13g2_decap_8
XFILLER_27_967 VPWR VGND sg13g2_decap_8
XFILLER_42_926 VPWR VGND sg13g2_decap_8
XFILLER_13_116 VPWR VGND sg13g2_decap_8
XFILLER_22_650 VPWR VGND sg13g2_decap_8
XFILLER_10_823 VPWR VGND sg13g2_decap_8
XFILLER_22_683 VPWR VGND sg13g2_fill_1
XFILLER_22_694 VPWR VGND sg13g2_decap_8
XFILLER_21_182 VPWR VGND sg13g2_decap_8
XFILLER_21_193 VPWR VGND sg13g2_fill_2
XFILLER_1_532 VPWR VGND sg13g2_decap_8
XFILLER_49_503 VPWR VGND sg13g2_decap_8
XFILLER_3_39 VPWR VGND sg13g2_decap_8
XFILLER_18_912 VPWR VGND sg13g2_decap_8
XFILLER_45_720 VPWR VGND sg13g2_fill_1
XFILLER_29_260 VPWR VGND sg13g2_decap_8
X_2883__73 VPWR VGND net73 sg13g2_tiehi
XFILLER_17_444 VPWR VGND sg13g2_decap_8
XFILLER_45_775 VPWR VGND sg13g2_decap_8
XFILLER_17_466 VPWR VGND sg13g2_decap_8
XFILLER_18_989 VPWR VGND sg13g2_decap_8
XFILLER_33_959 VPWR VGND sg13g2_decap_8
XFILLER_41_970 VPWR VGND sg13g2_decap_8
XFILLER_13_661 VPWR VGND sg13g2_decap_8
XFILLER_40_480 VPWR VGND sg13g2_decap_8
XFILLER_9_621 VPWR VGND sg13g2_decap_8
XFILLER_12_160 VPWR VGND sg13g2_decap_8
X_2650_ _1037_ _1038_ _1039_ VPWR VGND sg13g2_and2_1
XFILLER_8_197 VPWR VGND sg13g2_decap_8
XFILLER_9_698 VPWR VGND sg13g2_decap_8
X_1601_ _1254_ _1299_ _1300_ _1301_ VPWR VGND sg13g2_nor3_1
X_2581_ _0963_ VPWR _0970_ VGND _0937_ _0969_ sg13g2_o21ai_1
XFILLER_5_882 VPWR VGND sg13g2_decap_8
X_1532_ _1231_ VPWR _1233_ VGND _1121_ _1206_ sg13g2_o21ai_1
X_1463_ _1165_ net309 _0924_ VPWR VGND sg13g2_nand2_1
X_2015_ _0538_ _0483_ _0536_ VPWR VGND sg13g2_xnor2_1
XFILLER_35_230 VPWR VGND sg13g2_decap_8
XFILLER_23_414 VPWR VGND sg13g2_decap_8
XFILLER_24_926 VPWR VGND sg13g2_decap_8
X_2917_ net137 VGND VPWR _0138_ falutop.i2c_inst.data_in\[10\] clknet_5_27__leaf_clk
+ sg13g2_dfrbpq_1
XFILLER_12_26 VPWR VGND sg13g2_decap_8
X_2848_ net158 VGND VPWR _0069_ falutop.div_inst.val\[6\] clknet_5_16__leaf_clk sg13g2_dfrbpq_2
X_2779_ net125 VGND VPWR _0000_ falutop.div_inst.quo\[1\] clknet_5_17__leaf_clk sg13g2_dfrbpq_1
Xhold131 falutop.i2c_inst.op\[2\] VPWR VGND net432 sg13g2_dlygate4sd3_1
Xhold142 falutop.i2c_inst.result\[9\] VPWR VGND net443 sg13g2_dlygate4sd3_1
Xhold120 falutop.i2c_inst.data_in\[12\] VPWR VGND net421 sg13g2_dlygate4sd3_1
Xhold153 _0101_ VPWR VGND net454 sg13g2_dlygate4sd3_1
Xhold186 _0081_ VPWR VGND net487 sg13g2_dlygate4sd3_1
Xhold175 _0086_ VPWR VGND net476 sg13g2_dlygate4sd3_1
Xhold164 falutop.i2c_inst.result\[15\] VPWR VGND net465 sg13g2_dlygate4sd3_1
Xhold197 _0098_ VPWR VGND net498 sg13g2_dlygate4sd3_1
XFILLER_37_23 VPWR VGND sg13g2_decap_8
XFILLER_2_1012 VPWR VGND sg13g2_decap_8
XFILLER_14_403 VPWR VGND sg13g2_decap_8
XFILLER_15_915 VPWR VGND sg13g2_decap_8
XFILLER_27_775 VPWR VGND sg13g2_decap_4
XFILLER_23_981 VPWR VGND sg13g2_decap_8
XFILLER_10_631 VPWR VGND sg13g2_decap_8
XFILLER_6_657 VPWR VGND sg13g2_decap_8
XFILLER_5_123 VPWR VGND sg13g2_decap_4
XFILLER_10_697 VPWR VGND sg13g2_decap_8
XFILLER_2_830 VPWR VGND sg13g2_decap_8
XFILLER_37_506 VPWR VGND sg13g2_decap_8
XFILLER_37_517 VPWR VGND sg13g2_fill_1
XFILLER_17_252 VPWR VGND sg13g2_decap_4
XFILLER_18_764 VPWR VGND sg13g2_decap_8
XFILLER_32_200 VPWR VGND sg13g2_decap_8
XFILLER_33_745 VPWR VGND sg13g2_decap_8
XFILLER_21_918 VPWR VGND sg13g2_decap_8
XFILLER_32_244 VPWR VGND sg13g2_decap_8
XFILLER_33_778 VPWR VGND sg13g2_fill_1
X_2861__132 VPWR VGND net132 sg13g2_tiehi
XFILLER_9_462 VPWR VGND sg13g2_fill_1
X_2702_ _1090_ _0921_ _0933_ VPWR VGND sg13g2_xnor2_1
X_2633_ _1022_ _0986_ _1021_ VPWR VGND sg13g2_nand2b_1
X_2902__151 VPWR VGND net151 sg13g2_tiehi
X_2564_ _0925_ _0952_ _0953_ VPWR VGND sg13g2_and2_1
X_1515_ _1216_ net340 net317 net354 VPWR VGND sg13g2_and3_1
XFILLER_4_60 VPWR VGND sg13g2_decap_8
X_2495_ _0898_ _0899_ _0063_ VPWR VGND sg13g2_nor2_1
XFILLER_28_528 VPWR VGND sg13g2_fill_2
XFILLER_24_701 VPWR VGND sg13g2_decap_8
XFILLER_23_200 VPWR VGND sg13g2_decap_8
XFILLER_36_583 VPWR VGND sg13g2_decap_4
XFILLER_23_266 VPWR VGND sg13g2_decap_8
XFILLER_20_984 VPWR VGND sg13g2_decap_8
XFILLER_3_638 VPWR VGND sg13g2_decap_8
XFILLER_2_137 VPWR VGND sg13g2_decap_8
XFILLER_24_1024 VPWR VGND sg13g2_decap_4
XFILLER_47_826 VPWR VGND sg13g2_decap_8
XFILLER_14_200 VPWR VGND sg13g2_decap_8
XFILLER_15_756 VPWR VGND sg13g2_fill_2
XFILLER_42_575 VPWR VGND sg13g2_decap_8
XFILLER_30_726 VPWR VGND sg13g2_decap_8
XFILLER_11_951 VPWR VGND sg13g2_decap_8
XFILLER_7_955 VPWR VGND sg13g2_decap_8
XFILLER_6_454 VPWR VGND sg13g2_decap_8
XFILLER_43_7 VPWR VGND sg13g2_decap_8
X_2280_ _0705_ net376 _0746_ VPWR VGND sg13g2_nor2_1
XFILLER_29_5 VPWR VGND sg13g2_decap_4
XFILLER_38_848 VPWR VGND sg13g2_decap_8
XFILLER_37_303 VPWR VGND sg13g2_decap_4
XFILLER_38_859 VPWR VGND sg13g2_decap_4
XFILLER_37_358 VPWR VGND sg13g2_decap_4
XFILLER_18_550 VPWR VGND sg13g2_decap_8
XFILLER_18_594 VPWR VGND sg13g2_decap_8
XFILLER_33_520 VPWR VGND sg13g2_fill_2
XFILLER_33_542 VPWR VGND sg13g2_decap_8
X_1995_ VGND VPWR _0514_ _0518_ _0091_ _0475_ sg13g2_a21oi_1
X_2616_ falutop.alu_inst.op\[0\] falutop.alu_inst.op\[1\] falutop.alu_inst.op\[3\]
+ _1005_ VPWR VGND sg13g2_nor3_2
X_2547_ net327 net356 _0936_ VPWR VGND sg13g2_nor2_2
X_2478_ net201 _0893_ _0894_ VPWR VGND sg13g2_nor2_1
XFILLER_29_826 VPWR VGND sg13g2_decap_8
XFILLER_28_347 VPWR VGND sg13g2_fill_1
XFILLER_29_859 VPWR VGND sg13g2_decap_8
XFILLER_44_818 VPWR VGND sg13g2_decap_8
XFILLER_43_306 VPWR VGND sg13g2_decap_8
XFILLER_37_870 VPWR VGND sg13g2_fill_1
XFILLER_16_509 VPWR VGND sg13g2_fill_1
XFILLER_18_69 VPWR VGND sg13g2_decap_8
XFILLER_43_339 VPWR VGND sg13g2_fill_1
XFILLER_43_328 VPWR VGND sg13g2_decap_8
XFILLER_24_520 VPWR VGND sg13g2_decap_8
XFILLER_8_719 VPWR VGND sg13g2_decap_8
XFILLER_11_236 VPWR VGND sg13g2_fill_1
XFILLER_11_269 VPWR VGND sg13g2_decap_4
Xclkload1 VPWR clkload1/Y clknet_5_5__leaf_clk VGND sg13g2_inv_1
XFILLER_4_936 VPWR VGND sg13g2_decap_8
XFILLER_3_435 VPWR VGND sg13g2_decap_8
Xfanout271 net273 net271 VPWR VGND sg13g2_buf_8
Xfanout282 net283 net282 VPWR VGND sg13g2_buf_8
Xfanout293 net294 net293 VPWR VGND sg13g2_buf_8
XFILLER_46_166 VPWR VGND sg13g2_fill_2
XFILLER_19_369 VPWR VGND sg13g2_decap_8
X_1780_ _0306_ _0307_ _0308_ VPWR VGND sg13g2_nor2b_1
XFILLER_7_752 VPWR VGND sg13g2_decap_8
XFILLER_6_262 VPWR VGND sg13g2_fill_2
XFILLER_6_295 VPWR VGND sg13g2_decap_8
X_2401_ net380 net381 _0846_ VPWR VGND sg13g2_nor2b_2
X_2332_ _0791_ _0772_ _0773_ VPWR VGND sg13g2_xnor2_1
XFILLER_38_612 VPWR VGND sg13g2_decap_8
X_2263_ _0731_ _0728_ VPWR VGND _0729_ sg13g2_nand2b_2
X_2194_ VGND VPWR net382 _0672_ _0135_ _0673_ sg13g2_a21oi_1
XFILLER_18_391 VPWR VGND sg13g2_decap_8
XFILLER_34_862 VPWR VGND sg13g2_decap_8
XFILLER_33_361 VPWR VGND sg13g2_fill_2
XFILLER_21_567 VPWR VGND sg13g2_fill_1
X_1978_ _0500_ _0484_ _0502_ VPWR VGND sg13g2_xor2_1
XFILLER_20_15 VPWR VGND sg13g2_decap_8
XFILLER_1_917 VPWR VGND sg13g2_decap_8
XFILLER_0_427 VPWR VGND sg13g2_decap_8
Xhold13 _0003_ VPWR VGND net187 sg13g2_dlygate4sd3_1
Xhold46 falutop.i2c_inst.data_in\[18\] VPWR VGND net220 sg13g2_dlygate4sd3_1
Xhold24 _0128_ VPWR VGND net198 sg13g2_dlygate4sd3_1
Xhold35 _0065_ VPWR VGND net209 sg13g2_dlygate4sd3_1
XFILLER_29_57 VPWR VGND sg13g2_decap_8
XFILLER_29_601 VPWR VGND sg13g2_decap_8
Xhold79 _0032_ VPWR VGND net253 sg13g2_dlygate4sd3_1
XFILLER_21_1016 VPWR VGND sg13g2_decap_8
XFILLER_21_1027 VPWR VGND sg13g2_fill_2
Xhold57 _0011_ VPWR VGND net231 sg13g2_dlygate4sd3_1
XFILLER_28_100 VPWR VGND sg13g2_decap_8
Xhold68 falutop.div_inst.b\[1\] VPWR VGND net242 sg13g2_dlygate4sd3_1
XFILLER_29_678 VPWR VGND sg13g2_fill_1
XFILLER_44_637 VPWR VGND sg13g2_decap_8
XFILLER_43_114 VPWR VGND sg13g2_decap_8
XFILLER_16_328 VPWR VGND sg13g2_fill_1
XFILLER_43_158 VPWR VGND sg13g2_decap_8
XFILLER_43_169 VPWR VGND sg13g2_fill_2
XFILLER_24_361 VPWR VGND sg13g2_decap_8
XFILLER_24_372 VPWR VGND sg13g2_fill_1
XFILLER_31_309 VPWR VGND sg13g2_decap_8
XFILLER_12_523 VPWR VGND sg13g2_decap_8
XFILLER_40_898 VPWR VGND sg13g2_decap_8
XFILLER_6_39 VPWR VGND sg13g2_decap_8
XFILLER_4_733 VPWR VGND sg13g2_decap_8
XFILLER_3_221 VPWR VGND sg13g2_decap_8
XFILLER_48_910 VPWR VGND sg13g2_decap_8
XFILLER_47_431 VPWR VGND sg13g2_decap_8
XFILLER_47_420 VPWR VGND sg13g2_fill_1
XFILLER_0_994 VPWR VGND sg13g2_decap_8
XFILLER_13_8 VPWR VGND sg13g2_fill_2
XFILLER_19_100 VPWR VGND sg13g2_fill_1
XFILLER_48_987 VPWR VGND sg13g2_decap_8
XFILLER_34_114 VPWR VGND sg13g2_decap_8
XFILLER_16_840 VPWR VGND sg13g2_decap_8
XFILLER_37_1012 VPWR VGND sg13g2_decap_8
XFILLER_43_692 VPWR VGND sg13g2_decap_8
XFILLER_30_331 VPWR VGND sg13g2_fill_1
X_1901_ net337 net272 _0427_ VPWR VGND sg13g2_nor2_1
XFILLER_31_854 VPWR VGND sg13g2_decap_4
X_2881_ net77 VGND VPWR net516 falutop.alu_data_in\[5\] clknet_5_29__leaf_clk sg13g2_dfrbpq_1
XFILLER_30_353 VPWR VGND sg13g2_fill_1
X_1832_ _0359_ _0263_ _0358_ VPWR VGND sg13g2_xnor2_1
X_1763_ _0213_ VPWR _0292_ VGND _0214_ _0215_ sg13g2_o21ai_1
X_1694_ VGND VPWR _0942_ _1080_ _0224_ _1008_ sg13g2_a21oi_1
X_2315_ falutop.div_inst.acc\[2\] falutop.div_inst.b1\[2\] _0775_ VPWR VGND sg13g2_xor2_1
XFILLER_39_954 VPWR VGND sg13g2_decap_8
Xheichips25_template_26 VPWR VGND uo_out[6] sg13g2_tielo
Xheichips25_template_15 VPWR VGND uio_out[2] sg13g2_tielo
X_2246_ net385 _0714_ VPWR VGND sg13g2_inv_4
X_2177_ net386 VPWR _0662_ VGND net404 _0661_ sg13g2_o21ai_1
XFILLER_13_309 VPWR VGND sg13g2_decap_8
XFILLER_22_821 VPWR VGND sg13g2_fill_1
XFILLER_34_681 VPWR VGND sg13g2_decap_8
XFILLER_21_375 VPWR VGND sg13g2_decap_4
XFILLER_1_714 VPWR VGND sg13g2_decap_8
XFILLER_0_224 VPWR VGND sg13g2_decap_8
XFILLER_45_924 VPWR VGND sg13g2_decap_8
XFILLER_44_423 VPWR VGND sg13g2_decap_8
XFILLER_16_103 VPWR VGND sg13g2_fill_1
XFILLER_17_615 VPWR VGND sg13g2_fill_1
XFILLER_29_475 VPWR VGND sg13g2_decap_8
XFILLER_44_434 VPWR VGND sg13g2_fill_1
XFILLER_13_810 VPWR VGND sg13g2_decap_8
XFILLER_16_158 VPWR VGND sg13g2_fill_2
XFILLER_25_681 VPWR VGND sg13g2_decap_8
XFILLER_25_692 VPWR VGND sg13g2_fill_1
XFILLER_9_803 VPWR VGND sg13g2_decap_8
XFILLER_13_887 VPWR VGND sg13g2_decap_8
XFILLER_24_191 VPWR VGND sg13g2_decap_8
XFILLER_8_368 VPWR VGND sg13g2_decap_4
XFILLER_4_530 VPWR VGND sg13g2_decap_8
XFILLER_39_206 VPWR VGND sg13g2_decap_8
XFILLER_0_791 VPWR VGND sg13g2_decap_8
X_2100_ VGND VPWR _0724_ net285 _0104_ _0610_ sg13g2_a21oi_1
X_2031_ _0554_ falutop.div_inst.rem\[5\] _0552_ VPWR VGND sg13g2_xnor2_1
XFILLER_36_913 VPWR VGND sg13g2_decap_8
XFILLER_48_784 VPWR VGND sg13g2_decap_8
XFILLER_22_106 VPWR VGND sg13g2_decap_8
XFILLER_35_467 VPWR VGND sg13g2_decap_8
X_2799__78 VPWR VGND net78 sg13g2_tiehi
X_2864_ net126 VGND VPWR _0085_ falutop.i2c_inst.result\[6\] clknet_5_19__leaf_clk
+ sg13g2_dfrbpq_1
X_2795_ net82 VGND VPWR net215 falutop.i2c_inst.op\[0\] clknet_5_31__leaf_clk sg13g2_dfrbpq_1
X_2810__60 VPWR VGND net60 sg13g2_tiehi
XFILLER_30_183 VPWR VGND sg13g2_decap_8
X_1815_ _0339_ _0341_ _0338_ _0343_ VPWR VGND _0342_ sg13g2_nand4_1
XFILLER_8_880 VPWR VGND sg13g2_decap_8
X_1746_ VGND VPWR _1284_ _0272_ _0275_ _0274_ sg13g2_a21oi_1
X_1677_ _1290_ _0206_ _0207_ VPWR VGND sg13g2_nor2_1
X_2871__112 VPWR VGND net112 sg13g2_tiehi
X_2229_ net393 VPWR _0698_ VGND net220 _0697_ sg13g2_o21ai_1
XFILLER_27_946 VPWR VGND sg13g2_decap_8
XFILLER_42_905 VPWR VGND sg13g2_decap_8
XFILLER_26_69 VPWR VGND sg13g2_decap_8
XFILLER_26_489 VPWR VGND sg13g2_decap_8
XFILLER_35_990 VPWR VGND sg13g2_decap_8
XFILLER_10_802 VPWR VGND sg13g2_decap_8
XFILLER_21_161 VPWR VGND sg13g2_decap_8
XFILLER_10_879 VPWR VGND sg13g2_decap_8
XFILLER_6_839 VPWR VGND sg13g2_decap_8
XFILLER_5_316 VPWR VGND sg13g2_decap_4
XFILLER_1_511 VPWR VGND sg13g2_decap_8
XFILLER_3_18 VPWR VGND sg13g2_decap_8
XFILLER_1_588 VPWR VGND sg13g2_decap_8
XFILLER_49_559 VPWR VGND sg13g2_decap_8
XFILLER_17_412 VPWR VGND sg13g2_fill_2
XFILLER_45_754 VPWR VGND sg13g2_decap_8
XFILLER_17_423 VPWR VGND sg13g2_decap_8
XFILLER_18_968 VPWR VGND sg13g2_decap_8
XFILLER_33_938 VPWR VGND sg13g2_decap_8
X_2848__158 VPWR VGND net158 sg13g2_tiehi
XFILLER_16_80 VPWR VGND sg13g2_decap_8
XFILLER_9_600 VPWR VGND sg13g2_decap_8
XFILLER_13_640 VPWR VGND sg13g2_decap_8
XFILLER_32_459 VPWR VGND sg13g2_decap_8
XFILLER_8_110 VPWR VGND sg13g2_decap_8
XFILLER_13_695 VPWR VGND sg13g2_fill_1
XFILLER_9_677 VPWR VGND sg13g2_decap_8
X_1600_ VGND VPWR _1296_ _1298_ _1300_ _1242_ sg13g2_a21oi_1
X_2580_ VGND VPWR _0717_ net357 _0969_ _0968_ sg13g2_a21oi_1
XFILLER_5_861 VPWR VGND sg13g2_decap_8
X_1531_ _1121_ _1206_ _1231_ _1232_ VPWR VGND sg13g2_or3_1
X_2894__167 VPWR VGND net167 sg13g2_tiehi
XFILLER_41_1019 VPWR VGND sg13g2_decap_8
XFILLER_48_570 VPWR VGND sg13g2_decap_4
XFILLER_36_710 VPWR VGND sg13g2_fill_1
X_2014_ _0537_ _0536_ _0483_ VPWR VGND sg13g2_nand2b_1
XFILLER_36_754 VPWR VGND sg13g2_decap_8
XFILLER_24_905 VPWR VGND sg13g2_decap_8
XFILLER_35_264 VPWR VGND sg13g2_decap_8
XFILLER_32_993 VPWR VGND sg13g2_decap_8
X_2916_ net93 VGND VPWR _0137_ falutop.i2c_inst.data_in\[9\] clknet_5_24__leaf_clk
+ sg13g2_dfrbpq_1
X_2847_ net160 VGND VPWR net227 falutop.div_inst.val\[5\] clknet_5_17__leaf_clk sg13g2_dfrbpq_1
Xhold110 _0035_ VPWR VGND net411 sg13g2_dlygate4sd3_1
X_2778_ _1164_ _1130_ _1162_ VPWR VGND sg13g2_xnor2_1
Xhold143 _0088_ VPWR VGND net444 sg13g2_dlygate4sd3_1
XFILLER_2_319 VPWR VGND sg13g2_decap_8
Xhold132 _0049_ VPWR VGND net433 sg13g2_dlygate4sd3_1
X_1729_ _0193_ VPWR _0258_ VGND _1276_ _0194_ sg13g2_o21ai_1
Xhold121 _0040_ VPWR VGND net422 sg13g2_dlygate4sd3_1
Xhold154 falutop.i2c_inst.result\[6\] VPWR VGND net455 sg13g2_dlygate4sd3_1
Xhold165 _0094_ VPWR VGND net466 sg13g2_dlygate4sd3_1
Xhold176 falutop.i2c_inst.result\[14\] VPWR VGND net477 sg13g2_dlygate4sd3_1
Xhold187 falutop.div_inst.rem\[5\] VPWR VGND net488 sg13g2_dlygate4sd3_1
Xhold198 falutop.div_inst.rem\[3\] VPWR VGND net499 sg13g2_dlygate4sd3_1
XFILLER_26_264 VPWR VGND sg13g2_decap_8
XFILLER_42_735 VPWR VGND sg13g2_decap_8
XFILLER_41_212 VPWR VGND sg13g2_fill_1
XFILLER_26_297 VPWR VGND sg13g2_decap_8
XFILLER_42_768 VPWR VGND sg13g2_fill_1
XFILLER_42_757 VPWR VGND sg13g2_decap_8
XFILLER_23_960 VPWR VGND sg13g2_decap_8
XFILLER_10_610 VPWR VGND sg13g2_fill_2
XFILLER_6_636 VPWR VGND sg13g2_decap_8
XFILLER_10_676 VPWR VGND sg13g2_decap_8
XFILLER_5_168 VPWR VGND sg13g2_fill_1
XFILLER_2_886 VPWR VGND sg13g2_decap_8
XFILLER_1_385 VPWR VGND sg13g2_decap_8
XFILLER_18_743 VPWR VGND sg13g2_decap_8
XFILLER_18_754 VPWR VGND sg13g2_fill_1
XFILLER_45_562 VPWR VGND sg13g2_decap_8
XFILLER_17_231 VPWR VGND sg13g2_decap_8
XFILLER_27_90 VPWR VGND sg13g2_fill_2
XFILLER_33_757 VPWR VGND sg13g2_decap_8
XFILLER_32_267 VPWR VGND sg13g2_decap_8
XFILLER_9_441 VPWR VGND sg13g2_decap_8
X_2701_ _1089_ _0722_ _1005_ VPWR VGND sg13g2_nand2_1
XFILLER_9_474 VPWR VGND sg13g2_decap_8
XFILLER_9_496 VPWR VGND sg13g2_decap_4
X_2632_ net343 net337 _1021_ VPWR VGND sg13g2_nor2_1
X_2563_ _0951_ _0929_ _0952_ VPWR VGND sg13g2_xor2_1
X_1514_ _1201_ VPWR _1215_ VGND _1194_ _1202_ sg13g2_o21ai_1
X_2494_ net385 VPWR _0899_ VGND net507 net299 sg13g2_o21ai_1
XFILLER_24_746 VPWR VGND sg13g2_decap_8
XFILLER_23_245 VPWR VGND sg13g2_decap_8
XFILLER_24_768 VPWR VGND sg13g2_decap_8
XFILLER_23_15 VPWR VGND sg13g2_decap_8
XFILLER_20_963 VPWR VGND sg13g2_decap_8
XFILLER_3_617 VPWR VGND sg13g2_decap_8
XFILLER_2_116 VPWR VGND sg13g2_decap_8
XFILLER_24_1003 VPWR VGND sg13g2_decap_8
XFILLER_47_805 VPWR VGND sg13g2_decap_8
XFILLER_48_56 VPWR VGND sg13g2_fill_2
XFILLER_19_518 VPWR VGND sg13g2_decap_8
XFILLER_19_529 VPWR VGND sg13g2_fill_1
XFILLER_46_326 VPWR VGND sg13g2_fill_2
XFILLER_15_702 VPWR VGND sg13g2_fill_1
XFILLER_27_562 VPWR VGND sg13g2_fill_1
XFILLER_15_735 VPWR VGND sg13g2_decap_8
XFILLER_42_554 VPWR VGND sg13g2_decap_8
XFILLER_14_223 VPWR VGND sg13g2_fill_1
XFILLER_15_779 VPWR VGND sg13g2_decap_8
XFILLER_42_598 VPWR VGND sg13g2_decap_8
XFILLER_9_39 VPWR VGND sg13g2_decap_8
XFILLER_14_267 VPWR VGND sg13g2_decap_8
XFILLER_14_278 VPWR VGND sg13g2_fill_1
XFILLER_11_930 VPWR VGND sg13g2_decap_8
XFILLER_7_934 VPWR VGND sg13g2_decap_8
XFILLER_6_411 VPWR VGND sg13g2_fill_1
XFILLER_6_400 VPWR VGND sg13g2_decap_8
XFILLER_31_1018 VPWR VGND sg13g2_decap_8
XFILLER_2_683 VPWR VGND sg13g2_decap_8
XFILLER_1_182 VPWR VGND sg13g2_decap_8
XFILLER_49_142 VPWR VGND sg13g2_fill_2
XFILLER_49_197 VPWR VGND sg13g2_decap_8
XFILLER_37_337 VPWR VGND sg13g2_decap_8
XFILLER_18_540 VPWR VGND sg13g2_decap_4
XFILLER_21_716 VPWR VGND sg13g2_decap_8
X_1994_ VGND VPWR net305 _0517_ _0518_ net296 sg13g2_a21oi_1
XFILLER_20_259 VPWR VGND sg13g2_fill_2
XFILLER_9_293 VPWR VGND sg13g2_decap_8
X_2615_ falutop.alu_inst.op\[0\] falutop.alu_inst.op\[1\] _1004_ VPWR VGND sg13g2_nor2_1
XFILLER_0_609 VPWR VGND sg13g2_decap_8
X_2546_ net329 net354 _0935_ VPWR VGND sg13g2_and2_1
X_2477_ _0893_ net259 _0891_ VPWR VGND sg13g2_nand2_1
XFILLER_18_48 VPWR VGND sg13g2_fill_2
XFILLER_18_59 VPWR VGND sg13g2_fill_1
XFILLER_37_893 VPWR VGND sg13g2_decap_8
XFILLER_36_381 VPWR VGND sg13g2_fill_1
XFILLER_24_587 VPWR VGND sg13g2_fill_1
XFILLER_34_69 VPWR VGND sg13g2_fill_2
Xclkload2 VPWR clkload2/Y clknet_5_7__leaf_clk VGND sg13g2_inv_1
XFILLER_20_771 VPWR VGND sg13g2_decap_8
XFILLER_4_915 VPWR VGND sg13g2_decap_8
XFILLER_3_414 VPWR VGND sg13g2_decap_8
Xfanout283 _0979_ net283 VPWR VGND sg13g2_buf_8
Xfanout272 net273 net272 VPWR VGND sg13g2_buf_8
XFILLER_47_635 VPWR VGND sg13g2_decap_8
XFILLER_19_337 VPWR VGND sg13g2_decap_8
Xfanout294 _0862_ net294 VPWR VGND sg13g2_buf_8
XFILLER_47_679 VPWR VGND sg13g2_fill_2
XFILLER_46_145 VPWR VGND sg13g2_decap_8
XFILLER_35_808 VPWR VGND sg13g2_fill_1
XFILLER_15_554 VPWR VGND sg13g2_decap_8
XFILLER_27_381 VPWR VGND sg13g2_decap_8
XFILLER_43_885 VPWR VGND sg13g2_decap_8
XFILLER_15_565 VPWR VGND sg13g2_fill_2
XFILLER_30_513 VPWR VGND sg13g2_decap_8
XFILLER_30_579 VPWR VGND sg13g2_decap_4
XFILLER_7_731 VPWR VGND sg13g2_decap_8
XFILLER_10_292 VPWR VGND sg13g2_decap_8
XFILLER_6_241 VPWR VGND sg13g2_fill_2
X_2400_ net381 net380 _0845_ VPWR VGND sg13g2_nor2b_2
XFILLER_3_981 VPWR VGND sg13g2_decap_8
X_2331_ _0790_ net224 net277 VPWR VGND sg13g2_nand2_1
XFILLER_34_4 VPWR VGND sg13g2_fill_1
XFILLER_2_480 VPWR VGND sg13g2_decap_8
X_2262_ _0729_ _0728_ _0730_ VPWR VGND sg13g2_nor2b_2
X_2193_ net386 VPWR _0673_ VGND net410 _0672_ sg13g2_o21ai_1
XFILLER_1_84 VPWR VGND sg13g2_decap_8
XFILLER_19_893 VPWR VGND sg13g2_decap_8
XFILLER_21_502 VPWR VGND sg13g2_fill_1
XFILLER_21_546 VPWR VGND sg13g2_decap_8
X_1977_ VPWR _0501_ _0500_ VGND sg13g2_inv_1
XFILLER_0_406 VPWR VGND sg13g2_decap_8
X_2529_ _0916_ _0917_ _0918_ VPWR VGND sg13g2_and2_1
Xhold14 falutop.div_inst.quo\[6\] VPWR VGND net188 sg13g2_dlygate4sd3_1
Xhold47 _0018_ VPWR VGND net221 sg13g2_dlygate4sd3_1
Xhold25 falutop.div_inst.quo\[3\] VPWR VGND net199 sg13g2_dlygate4sd3_1
Xhold36 falutop.div_inst.a\[3\] VPWR VGND net210 sg13g2_dlygate4sd3_1
XFILLER_29_47 VPWR VGND sg13g2_fill_1
Xhold58 falutop.div_inst.i\[0\] VPWR VGND net232 sg13g2_dlygate4sd3_1
XFILLER_29_646 VPWR VGND sg13g2_decap_4
Xhold69 _0121_ VPWR VGND net243 sg13g2_dlygate4sd3_1
XFILLER_43_137 VPWR VGND sg13g2_decap_8
X_2823__47 VPWR VGND net47 sg13g2_tiehi
XFILLER_12_502 VPWR VGND sg13g2_decap_8
XFILLER_25_885 VPWR VGND sg13g2_fill_2
XFILLER_40_833 VPWR VGND sg13g2_decap_8
XFILLER_24_384 VPWR VGND sg13g2_fill_2
XFILLER_40_877 VPWR VGND sg13g2_decap_8
X_2922__133 VPWR VGND net133 sg13g2_tiehi
XFILLER_6_18 VPWR VGND sg13g2_decap_8
XFILLER_4_712 VPWR VGND sg13g2_decap_8
XFILLER_3_200 VPWR VGND sg13g2_decap_8
XFILLER_10_60 VPWR VGND sg13g2_decap_8
XFILLER_4_789 VPWR VGND sg13g2_decap_8
XFILLER_3_288 VPWR VGND sg13g2_decap_8
XFILLER_0_973 VPWR VGND sg13g2_decap_8
XFILLER_48_966 VPWR VGND sg13g2_decap_8
XFILLER_19_80 VPWR VGND sg13g2_fill_2
XFILLER_19_145 VPWR VGND sg13g2_decap_8
XFILLER_35_627 VPWR VGND sg13g2_fill_2
XFILLER_43_671 VPWR VGND sg13g2_decap_8
XFILLER_31_800 VPWR VGND sg13g2_decap_4
XFILLER_31_811 VPWR VGND sg13g2_decap_4
XFILLER_34_159 VPWR VGND sg13g2_decap_8
XFILLER_42_181 VPWR VGND sg13g2_decap_8
X_1900_ VGND VPWR _0425_ _0426_ _0424_ _0422_ sg13g2_a21oi_2
XFILLER_16_896 VPWR VGND sg13g2_decap_8
XFILLER_30_310 VPWR VGND sg13g2_decap_8
XFILLER_31_844 VPWR VGND sg13g2_fill_2
XFILLER_35_90 VPWR VGND sg13g2_fill_2
X_2880_ net83 VGND VPWR net454 falutop.alu_data_in\[4\] clknet_5_12__leaf_clk sg13g2_dfrbpq_2
X_1831_ VGND VPWR _0915_ _0935_ _0358_ _0357_ sg13g2_a21oi_1
XFILLER_30_365 VPWR VGND sg13g2_decap_8
XFILLER_31_899 VPWR VGND sg13g2_decap_8
XFILLER_11_590 VPWR VGND sg13g2_decap_8
X_1762_ _0289_ _0288_ _0291_ VPWR VGND sg13g2_xor2_1
X_1693_ _0971_ _0944_ _0223_ VPWR VGND sg13g2_xor2_1
X_2858__138 VPWR VGND net138 sg13g2_tiehi
XFILLER_44_1028 VPWR VGND sg13g2_fill_1
X_2314_ VGND VPWR _0772_ _0773_ _0774_ _0771_ sg13g2_a21oi_1
X_2245_ _0713_ net432 VPWR VGND sg13g2_inv_2
XFILLER_39_933 VPWR VGND sg13g2_decap_8
Xheichips25_template_27 VPWR VGND uo_out[7] sg13g2_tielo
Xheichips25_template_16 VPWR VGND uio_out[3] sg13g2_tielo
X_2176_ _0835_ _0660_ _0661_ VPWR VGND sg13g2_nor2_1
XFILLER_38_454 VPWR VGND sg13g2_decap_8
XFILLER_40_107 VPWR VGND sg13g2_decap_8
XFILLER_15_38 VPWR VGND sg13g2_fill_2
XFILLER_22_800 VPWR VGND sg13g2_fill_1
XFILLER_34_660 VPWR VGND sg13g2_fill_1
XFILLER_22_833 VPWR VGND sg13g2_decap_8
XFILLER_33_181 VPWR VGND sg13g2_decap_8
XFILLER_0_203 VPWR VGND sg13g2_decap_8
XFILLER_5_1022 VPWR VGND sg13g2_decap_8
XFILLER_45_903 VPWR VGND sg13g2_decap_8
XFILLER_29_454 VPWR VGND sg13g2_decap_8
XFILLER_44_402 VPWR VGND sg13g2_decap_8
XFILLER_17_627 VPWR VGND sg13g2_decap_8
XFILLER_17_638 VPWR VGND sg13g2_fill_1
XFILLER_44_446 VPWR VGND sg13g2_decap_8
XFILLER_16_137 VPWR VGND sg13g2_decap_8
XFILLER_25_660 VPWR VGND sg13g2_decap_8
XFILLER_32_608 VPWR VGND sg13g2_decap_8
XFILLER_13_866 VPWR VGND sg13g2_decap_8
XFILLER_40_674 VPWR VGND sg13g2_decap_8
XFILLER_9_859 VPWR VGND sg13g2_decap_8
XFILLER_4_586 VPWR VGND sg13g2_decap_8
XFILLER_21_92 VPWR VGND sg13g2_fill_1
XFILLER_0_770 VPWR VGND sg13g2_decap_8
XFILLER_48_763 VPWR VGND sg13g2_decap_8
X_2030_ _0553_ net370 falutop.div_inst.rem\[5\] VPWR VGND sg13g2_nand2_1
XFILLER_47_262 VPWR VGND sg13g2_decap_8
XFILLER_35_446 VPWR VGND sg13g2_decap_8
XFILLER_36_969 VPWR VGND sg13g2_decap_8
XFILLER_16_660 VPWR VGND sg13g2_decap_8
XFILLER_16_693 VPWR VGND sg13g2_fill_2
XFILLER_15_192 VPWR VGND sg13g2_fill_2
XFILLER_31_663 VPWR VGND sg13g2_decap_8
X_2863_ net128 VGND VPWR net464 falutop.i2c_inst.result\[5\] clknet_5_19__leaf_clk
+ sg13g2_dfrbpq_1
X_2794_ net84 VGND VPWR _0015_ falutop.div_inst.acc\[8\] clknet_5_0__leaf_clk sg13g2_dfrbpq_1
X_1814_ _1001_ VPWR _0342_ VGND _0241_ _0243_ sg13g2_o21ai_1
X_1745_ _0274_ net351 net335 falutop.alu_data_in\[6\] net340 VPWR VGND sg13g2_a22oi_1
X_1676_ _0206_ _0200_ _0204_ VPWR VGND sg13g2_xnor2_1
X_2228_ _0652_ _0660_ _0697_ VPWR VGND sg13g2_nor2_1
XFILLER_27_925 VPWR VGND sg13g2_decap_8
X_2159_ VGND VPWR net291 _0648_ _0125_ _0646_ sg13g2_a21oi_1
XFILLER_26_468 VPWR VGND sg13g2_decap_8
XFILLER_41_427 VPWR VGND sg13g2_decap_8
XFILLER_22_674 VPWR VGND sg13g2_decap_8
XFILLER_6_818 VPWR VGND sg13g2_decap_8
XFILLER_10_858 VPWR VGND sg13g2_decap_8
XFILLER_5_339 VPWR VGND sg13g2_decap_8
XFILLER_1_567 VPWR VGND sg13g2_decap_8
XFILLER_27_1023 VPWR VGND sg13g2_decap_4
XFILLER_49_538 VPWR VGND sg13g2_decap_8
XFILLER_45_733 VPWR VGND sg13g2_decap_8
XFILLER_44_221 VPWR VGND sg13g2_decap_8
XFILLER_18_947 VPWR VGND sg13g2_decap_8
XFILLER_44_243 VPWR VGND sg13g2_decap_8
XFILLER_33_917 VPWR VGND sg13g2_decap_8
XFILLER_32_416 VPWR VGND sg13g2_decap_8
XFILLER_40_460 VPWR VGND sg13g2_fill_1
XFILLER_34_1016 VPWR VGND sg13g2_decap_8
XFILLER_34_1027 VPWR VGND sg13g2_fill_2
XFILLER_8_144 VPWR VGND sg13g2_fill_2
XFILLER_9_656 VPWR VGND sg13g2_decap_8
XFILLER_8_177 VPWR VGND sg13g2_decap_4
XFILLER_8_166 VPWR VGND sg13g2_fill_2
XFILLER_5_840 VPWR VGND sg13g2_decap_8
X_1530_ _1231_ _1228_ _1229_ VPWR VGND sg13g2_xnor2_1
XFILLER_4_383 VPWR VGND sg13g2_decap_8
X_2013_ _0535_ _0519_ _0536_ VPWR VGND sg13g2_xor2_1
XFILLER_36_733 VPWR VGND sg13g2_decap_8
XFILLER_17_980 VPWR VGND sg13g2_decap_8
XFILLER_16_490 VPWR VGND sg13g2_fill_2
XFILLER_23_449 VPWR VGND sg13g2_decap_8
XFILLER_32_972 VPWR VGND sg13g2_decap_8
X_2915_ net107 VGND VPWR _0136_ falutop.i2c_inst.data_in\[8\] clknet_5_24__leaf_clk
+ sg13g2_dfrbpq_1
X_2846_ net162 VGND VPWR net399 falutop.div_inst.val\[4\] clknet_5_17__leaf_clk sg13g2_dfrbpq_1
X_2795__82 VPWR VGND net82 sg13g2_tiehi
Xhold100 _0817_ VPWR VGND net401 sg13g2_dlygate4sd3_1
X_2777_ _1130_ _1162_ _1163_ VPWR VGND sg13g2_nor2b_1
Xhold133 falutop.i2c_inst.counter\[4\] VPWR VGND net434 sg13g2_dlygate4sd3_1
Xhold122 falutop.i2c_inst.data_in\[6\] VPWR VGND net423 sg13g2_dlygate4sd3_1
Xhold144 falutop.i2c_inst.data_in\[5\] VPWR VGND net445 sg13g2_dlygate4sd3_1
X_1728_ _0252_ _0255_ _0248_ _0257_ VPWR VGND _0256_ sg13g2_nand4_1
Xhold111 falutop.div_inst.b\[3\] VPWR VGND net412 sg13g2_dlygate4sd3_1
Xhold155 falutop.i2c_inst.op\[1\] VPWR VGND net456 sg13g2_dlygate4sd3_1
Xhold166 falutop.i2c_inst.result\[8\] VPWR VGND net467 sg13g2_dlygate4sd3_1
X_1659_ net331 net365 net325 _0189_ VPWR VGND net362 sg13g2_nand4_1
Xhold177 _0093_ VPWR VGND net478 sg13g2_dlygate4sd3_1
Xhold188 falutop.div_inst.rem\[7\] VPWR VGND net489 sg13g2_dlygate4sd3_1
Xhold199 falutop.alu_data_in\[0\] VPWR VGND net500 sg13g2_dlygate4sd3_1
XFILLER_37_58 VPWR VGND sg13g2_decap_8
XFILLER_37_69 VPWR VGND sg13g2_fill_1
XFILLER_27_733 VPWR VGND sg13g2_decap_8
XFILLER_26_243 VPWR VGND sg13g2_decap_8
XFILLER_27_755 VPWR VGND sg13g2_fill_1
XFILLER_41_224 VPWR VGND sg13g2_decap_8
XFILLER_14_438 VPWR VGND sg13g2_decap_8
XFILLER_41_246 VPWR VGND sg13g2_decap_8
XFILLER_41_279 VPWR VGND sg13g2_decap_8
XFILLER_6_615 VPWR VGND sg13g2_decap_8
XFILLER_10_655 VPWR VGND sg13g2_decap_8
XFILLER_10_666 VPWR VGND sg13g2_fill_2
XFILLER_2_865 VPWR VGND sg13g2_decap_8
XFILLER_49_324 VPWR VGND sg13g2_decap_8
XFILLER_1_364 VPWR VGND sg13g2_decap_8
XFILLER_49_368 VPWR VGND sg13g2_decap_8
XFILLER_17_210 VPWR VGND sg13g2_fill_2
XFILLER_17_221 VPWR VGND sg13g2_fill_1
XFILLER_45_541 VPWR VGND sg13g2_decap_8
XFILLER_33_703 VPWR VGND sg13g2_decap_8
XFILLER_45_585 VPWR VGND sg13g2_decap_8
XFILLER_33_725 VPWR VGND sg13g2_decap_8
XFILLER_32_224 VPWR VGND sg13g2_fill_2
XFILLER_14_983 VPWR VGND sg13g2_decap_8
XFILLER_9_431 VPWR VGND sg13g2_fill_1
X_2700_ _0722_ _1005_ _1088_ VPWR VGND sg13g2_and2_1
X_2631_ net369 _1004_ _0722_ _1020_ VPWR VGND sg13g2_nand3_1
X_2562_ _0951_ _0934_ _0949_ VPWR VGND sg13g2_xnor2_1
X_1513_ _1214_ net333 net325 VPWR VGND sg13g2_nand2_1
X_2493_ net270 net298 _0898_ VPWR VGND sg13g2_nor2b_1
XFILLER_4_95 VPWR VGND sg13g2_decap_8
XFILLER_24_725 VPWR VGND sg13g2_decap_8
XFILLER_17_1022 VPWR VGND sg13g2_decap_8
XFILLER_20_942 VPWR VGND sg13g2_decap_8
Xclkbuf_5_18__f_clk clknet_4_9_0_clk clknet_5_18__leaf_clk VPWR VGND sg13g2_buf_8
X_2829_ net39 VGND VPWR net403 falutop.alu_inst.op\[3\] clknet_5_23__leaf_clk sg13g2_dfrbpq_2
XFILLER_48_35 VPWR VGND sg13g2_decap_8
XFILLER_46_305 VPWR VGND sg13g2_decap_4
XFILLER_27_585 VPWR VGND sg13g2_fill_2
XFILLER_9_18 VPWR VGND sg13g2_decap_8
XFILLER_15_758 VPWR VGND sg13g2_fill_1
XFILLER_7_913 VPWR VGND sg13g2_decap_8
XFILLER_11_986 VPWR VGND sg13g2_decap_8
XFILLER_10_474 VPWR VGND sg13g2_fill_1
XFILLER_6_489 VPWR VGND sg13g2_decap_8
XFILLER_2_662 VPWR VGND sg13g2_decap_8
XFILLER_1_161 VPWR VGND sg13g2_decap_8
XFILLER_49_121 VPWR VGND sg13g2_decap_8
XFILLER_49_176 VPWR VGND sg13g2_decap_8
XFILLER_37_316 VPWR VGND sg13g2_decap_8
XFILLER_38_90 VPWR VGND sg13g2_fill_2
XFILLER_46_883 VPWR VGND sg13g2_decap_8
XFILLER_33_577 VPWR VGND sg13g2_fill_2
XFILLER_20_238 VPWR VGND sg13g2_decap_8
X_1993_ _0517_ falutop.div_inst.rem\[4\] _0515_ VPWR VGND sg13g2_xnor2_1
XFILLER_9_261 VPWR VGND sg13g2_decap_4
X_2614_ VGND VPWR net328 net309 _1003_ _1002_ sg13g2_a21oi_1
XFILLER_47_1015 VPWR VGND sg13g2_decap_8
X_2545_ VGND VPWR _0934_ _0932_ net308 sg13g2_or2_1
X_2476_ _0051_ net233 _0729_ _0891_ _0728_ VPWR VGND sg13g2_a22oi_1
X_2868__118 VPWR VGND net118 sg13g2_tiehi
XFILLER_12_728 VPWR VGND sg13g2_decap_4
XFILLER_24_566 VPWR VGND sg13g2_fill_1
Xclkload3 VPWR clkload3/Y clknet_5_11__leaf_clk VGND sg13g2_inv_1
XFILLER_20_750 VPWR VGND sg13g2_decap_8
XFILLER_8_1020 VPWR VGND sg13g2_decap_8
Xfanout273 _0975_ net273 VPWR VGND sg13g2_buf_8
XFILLER_46_124 VPWR VGND sg13g2_decap_8
Xfanout284 net287 net284 VPWR VGND sg13g2_buf_8
XFILLER_19_316 VPWR VGND sg13g2_decap_8
Xfanout295 _0861_ net295 VPWR VGND sg13g2_buf_8
XFILLER_27_360 VPWR VGND sg13g2_decap_8
XFILLER_28_883 VPWR VGND sg13g2_decap_8
XFILLER_15_533 VPWR VGND sg13g2_decap_8
XFILLER_43_864 VPWR VGND sg13g2_decap_8
XFILLER_42_363 VPWR VGND sg13g2_decap_8
XFILLER_42_341 VPWR VGND sg13g2_decap_4
XFILLER_30_558 VPWR VGND sg13g2_decap_8
XFILLER_10_271 VPWR VGND sg13g2_decap_8
XFILLER_7_710 VPWR VGND sg13g2_decap_8
XFILLER_11_783 VPWR VGND sg13g2_decap_8
XFILLER_7_787 VPWR VGND sg13g2_decap_8
XFILLER_6_264 VPWR VGND sg13g2_fill_1
XFILLER_3_960 VPWR VGND sg13g2_decap_8
X_2330_ _0764_ VPWR _0008_ VGND _0731_ _0789_ sg13g2_o21ai_1
X_2261_ _0729_ net429 VPWR VGND net374 sg13g2_nand2b_2
X_2192_ _0653_ _0665_ _0672_ VPWR VGND sg13g2_nor2_1
XFILLER_38_636 VPWR VGND sg13g2_decap_8
XFILLER_1_63 VPWR VGND sg13g2_decap_8
XFILLER_46_680 VPWR VGND sg13g2_decap_4
XFILLER_18_360 VPWR VGND sg13g2_fill_1
XFILLER_19_872 VPWR VGND sg13g2_decap_8
XFILLER_34_842 VPWR VGND sg13g2_fill_1
XFILLER_21_525 VPWR VGND sg13g2_decap_8
XFILLER_33_374 VPWR VGND sg13g2_fill_2
XFILLER_34_897 VPWR VGND sg13g2_decap_8
X_1976_ _0498_ _0485_ _0500_ VPWR VGND sg13g2_xor2_1
XFILLER_14_1025 VPWR VGND sg13g2_decap_4
X_2528_ VGND VPWR _0917_ net352 net324 sg13g2_or2_1
X_2459_ _0878_ _0882_ net436 _0883_ VPWR VGND sg13g2_nand3_1
Xhold26 _0002_ VPWR VGND net200 sg13g2_dlygate4sd3_1
Xhold15 _0005_ VPWR VGND net189 sg13g2_dlygate4sd3_1
Xhold37 _0116_ VPWR VGND net211 sg13g2_dlygate4sd3_1
Xhold59 _0892_ VPWR VGND net233 sg13g2_dlygate4sd3_1
XFILLER_29_625 VPWR VGND sg13g2_decap_8
Xhold48 falutop.div_inst.b\[6\] VPWR VGND net222 sg13g2_dlygate4sd3_1
XFILLER_44_606 VPWR VGND sg13g2_decap_8
XFILLER_28_135 VPWR VGND sg13g2_decap_8
XFILLER_45_47 VPWR VGND sg13g2_decap_8
XFILLER_37_680 VPWR VGND sg13g2_decap_8
XFILLER_40_812 VPWR VGND sg13g2_decap_8
XFILLER_25_864 VPWR VGND sg13g2_decap_8
XFILLER_40_856 VPWR VGND sg13g2_decap_8
XFILLER_20_580 VPWR VGND sg13g2_decap_8
XFILLER_4_768 VPWR VGND sg13g2_decap_8
XFILLER_3_256 VPWR VGND sg13g2_decap_4
XFILLER_10_94 VPWR VGND sg13g2_decap_8
XFILLER_0_952 VPWR VGND sg13g2_decap_8
XFILLER_48_945 VPWR VGND sg13g2_decap_8
XFILLER_47_411 VPWR VGND sg13g2_decap_8
XFILLER_19_135 VPWR VGND sg13g2_decap_4
XFILLER_35_617 VPWR VGND sg13g2_decap_4
XFILLER_16_820 VPWR VGND sg13g2_fill_1
XFILLER_34_149 VPWR VGND sg13g2_decap_4
XFILLER_15_330 VPWR VGND sg13g2_fill_2
XFILLER_16_875 VPWR VGND sg13g2_decap_8
XFILLER_15_374 VPWR VGND sg13g2_decap_8
XFILLER_31_823 VPWR VGND sg13g2_decap_4
XFILLER_31_878 VPWR VGND sg13g2_decap_8
X_1830_ _0357_ net351 net330 net355 net326 VPWR VGND sg13g2_a22oi_1
X_1761_ _0288_ _0289_ _0290_ VPWR VGND sg13g2_nor2_1
XFILLER_7_584 VPWR VGND sg13g2_decap_8
X_1692_ _0944_ _0971_ _0222_ VPWR VGND sg13g2_nor2_1
XFILLER_44_1007 VPWR VGND sg13g2_decap_8
X_2313_ _0773_ falutop.div_inst.b1\[1\] falutop.div_inst.acc\[1\] VPWR VGND sg13g2_xnor2_1
XFILLER_39_912 VPWR VGND sg13g2_decap_8
X_2244_ _0712_ net402 VPWR VGND sg13g2_inv_2
Xheichips25_template_17 VPWR VGND uio_out[4] sg13g2_tielo
X_2175_ _0660_ _0824_ _0845_ VPWR VGND sg13g2_nand2_2
XFILLER_39_989 VPWR VGND sg13g2_decap_8
XFILLER_38_477 VPWR VGND sg13g2_decap_8
XFILLER_25_138 VPWR VGND sg13g2_fill_2
XFILLER_25_149 VPWR VGND sg13g2_fill_2
XFILLER_22_878 VPWR VGND sg13g2_fill_2
X_1959_ _0483_ _0350_ _0482_ VPWR VGND sg13g2_nand2_1
XFILLER_1_749 VPWR VGND sg13g2_decap_8
XFILLER_0_259 VPWR VGND sg13g2_decap_8
XFILLER_5_1001 VPWR VGND sg13g2_decap_8
XFILLER_45_959 VPWR VGND sg13g2_decap_8
XFILLER_24_160 VPWR VGND sg13g2_fill_2
XFILLER_24_171 VPWR VGND sg13g2_decap_8
XFILLER_40_653 VPWR VGND sg13g2_fill_2
XFILLER_13_845 VPWR VGND sg13g2_decap_8
XFILLER_9_838 VPWR VGND sg13g2_decap_8
XFILLER_12_366 VPWR VGND sg13g2_decap_8
XFILLER_4_565 VPWR VGND sg13g2_decap_8
XFILLER_48_742 VPWR VGND sg13g2_decap_8
XFILLER_47_252 VPWR VGND sg13g2_fill_1
XFILLER_35_425 VPWR VGND sg13g2_decap_8
XFILLER_36_948 VPWR VGND sg13g2_decap_8
XFILLER_15_171 VPWR VGND sg13g2_decap_8
XFILLER_16_672 VPWR VGND sg13g2_decap_8
Xclkbuf_0_clk clk clknet_0_clk VPWR VGND sg13g2_buf_8
XFILLER_31_642 VPWR VGND sg13g2_decap_8
X_2862_ net130 VGND VPWR _0083_ falutop.i2c_inst.result\[4\] clknet_5_16__leaf_clk
+ sg13g2_dfrbpq_1
X_2793_ net86 VGND VPWR net229 falutop.div_inst.acc\[7\] clknet_5_0__leaf_clk sg13g2_dfrbpq_1
XFILLER_30_174 VPWR VGND sg13g2_decap_4
X_1813_ _0976_ _0716_ _0340_ _0341_ VPWR VGND sg13g2_a21o_1
XFILLER_11_1028 VPWR VGND sg13g2_fill_1
X_1744_ _0273_ _1284_ _0272_ VPWR VGND sg13g2_nand2_1
XFILLER_7_370 VPWR VGND sg13g2_fill_2
XFILLER_7_84 VPWR VGND sg13g2_decap_8
X_1675_ _0205_ _0200_ _0204_ VPWR VGND sg13g2_nand2_1
X_2227_ VGND VPWR net383 _0695_ _0145_ _0696_ sg13g2_a21oi_1
XFILLER_38_230 VPWR VGND sg13g2_decap_8
XFILLER_39_786 VPWR VGND sg13g2_fill_1
XFILLER_27_904 VPWR VGND sg13g2_decap_8
XFILLER_26_414 VPWR VGND sg13g2_fill_1
XFILLER_26_447 VPWR VGND sg13g2_decap_8
X_2158_ _0648_ falutop.data_in\[5\] _0647_ VPWR VGND sg13g2_xnor2_1
X_2089_ VPWR _0096_ net480 VGND sg13g2_inv_1
XFILLER_13_108 VPWR VGND sg13g2_fill_2
XFILLER_42_48 VPWR VGND sg13g2_fill_2
XFILLER_10_837 VPWR VGND sg13g2_decap_8
XFILLER_27_1002 VPWR VGND sg13g2_decap_8
XFILLER_1_546 VPWR VGND sg13g2_decap_8
XFILLER_49_517 VPWR VGND sg13g2_decap_8
XFILLER_18_926 VPWR VGND sg13g2_decap_8
XFILLER_17_414 VPWR VGND sg13g2_fill_1
XFILLER_29_274 VPWR VGND sg13g2_decap_8
XFILLER_29_285 VPWR VGND sg13g2_fill_2
XFILLER_45_789 VPWR VGND sg13g2_fill_2
XFILLER_17_458 VPWR VGND sg13g2_fill_2
XFILLER_44_277 VPWR VGND sg13g2_decap_8
XFILLER_13_620 VPWR VGND sg13g2_decap_8
XFILLER_41_984 VPWR VGND sg13g2_decap_8
XFILLER_9_635 VPWR VGND sg13g2_fill_1
XFILLER_13_686 VPWR VGND sg13g2_decap_8
XFILLER_12_174 VPWR VGND sg13g2_decap_8
XFILLER_5_896 VPWR VGND sg13g2_decap_8
X_2012_ _0535_ _0523_ _0534_ VPWR VGND sg13g2_xnor2_1
XFILLER_48_583 VPWR VGND sg13g2_decap_8
XFILLER_35_244 VPWR VGND sg13g2_fill_2
XFILLER_36_778 VPWR VGND sg13g2_decap_8
XFILLER_36_789 VPWR VGND sg13g2_fill_2
XFILLER_23_428 VPWR VGND sg13g2_fill_2
XFILLER_32_951 VPWR VGND sg13g2_decap_8
X_2914_ net111 VGND VPWR _0135_ falutop.i2c_inst.data_in\[7\] clknet_5_11__leaf_clk
+ sg13g2_dfrbpq_1
X_2845_ net164 VGND VPWR _0066_ falutop.div_inst.val\[3\] clknet_5_20__leaf_clk sg13g2_dfrbpq_2
Xhold101 falutop.i2c_inst.op\[3\] VPWR VGND net402 sg13g2_dlygate4sd3_1
X_2776_ VGND VPWR _0926_ net308 _1162_ _1161_ sg13g2_a21oi_1
Xhold134 falutop.i2c_inst.counter\[2\] VPWR VGND net435 sg13g2_dlygate4sd3_1
Xhold123 _0034_ VPWR VGND net424 sg13g2_dlygate4sd3_1
X_1727_ VPWR VGND _0941_ _0254_ _1080_ _0938_ _0256_ _1014_ sg13g2_a221oi_1
Xhold112 _0123_ VPWR VGND net413 sg13g2_dlygate4sd3_1
Xhold156 _0890_ VPWR VGND net457 sg13g2_dlygate4sd3_1
Xhold145 _0033_ VPWR VGND net446 sg13g2_dlygate4sd3_1
Xhold167 _0087_ VPWR VGND net468 sg13g2_dlygate4sd3_1
X_1658_ _0188_ net325 net362 VPWR VGND sg13g2_nand2_1
Xhold189 falutop.data_in\[3\] VPWR VGND net490 sg13g2_dlygate4sd3_1
Xhold178 falutop.div_inst.b\[7\] VPWR VGND net479 sg13g2_dlygate4sd3_1
X_1589_ net335 net358 _1287_ _1288_ _1289_ VPWR VGND sg13g2_and4_1
XFILLER_37_37 VPWR VGND sg13g2_decap_8
XFILLER_27_701 VPWR VGND sg13g2_decap_8
XFILLER_39_583 VPWR VGND sg13g2_decap_4
XFILLER_2_1026 VPWR VGND sg13g2_fill_2
XFILLER_26_211 VPWR VGND sg13g2_fill_2
XFILLER_26_222 VPWR VGND sg13g2_decap_8
XFILLER_14_417 VPWR VGND sg13g2_decap_8
XFILLER_15_929 VPWR VGND sg13g2_decap_8
X_2847__160 VPWR VGND net160 sg13g2_tiehi
XFILLER_22_483 VPWR VGND sg13g2_decap_8
XFILLER_23_995 VPWR VGND sg13g2_decap_8
XFILLER_5_159 VPWR VGND sg13g2_decap_8
XFILLER_2_844 VPWR VGND sg13g2_decap_8
XFILLER_1_343 VPWR VGND sg13g2_decap_8
XFILLER_49_303 VPWR VGND sg13g2_decap_8
XFILLER_49_347 VPWR VGND sg13g2_decap_8
XFILLER_40_1010 VPWR VGND sg13g2_decap_8
XFILLER_18_712 VPWR VGND sg13g2_decap_8
XFILLER_18_778 VPWR VGND sg13g2_decap_8
XFILLER_18_789 VPWR VGND sg13g2_fill_2
XFILLER_9_410 VPWR VGND sg13g2_fill_2
XFILLER_14_962 VPWR VGND sg13g2_decap_8
XFILLER_20_409 VPWR VGND sg13g2_decap_8
XFILLER_32_258 VPWR VGND sg13g2_decap_4
XFILLER_43_91 VPWR VGND sg13g2_decap_8
XFILLER_41_781 VPWR VGND sg13g2_decap_8
XFILLER_13_472 VPWR VGND sg13g2_fill_2
XFILLER_40_291 VPWR VGND sg13g2_fill_1
X_2630_ VGND VPWR _1019_ _0977_ _0958_ sg13g2_or2_1
X_2561_ _0933_ _0949_ _0950_ VPWR VGND sg13g2_and2_1
XFILLER_5_693 VPWR VGND sg13g2_decap_8
X_2492_ _0714_ _0738_ _0062_ VPWR VGND sg13g2_nor2_1
X_1512_ _1212_ _1213_ _0082_ VPWR VGND sg13g2_nor2_1
XFILLER_4_74 VPWR VGND sg13g2_decap_8
XFILLER_28_509 VPWR VGND sg13g2_fill_2
XFILLER_49_881 VPWR VGND sg13g2_decap_8
XFILLER_48_380 VPWR VGND sg13g2_decap_4
XFILLER_36_520 VPWR VGND sg13g2_decap_8
XFILLER_36_553 VPWR VGND sg13g2_decap_8
XFILLER_23_214 VPWR VGND sg13g2_decap_8
XFILLER_24_715 VPWR VGND sg13g2_decap_4
XFILLER_36_597 VPWR VGND sg13g2_decap_8
XFILLER_11_409 VPWR VGND sg13g2_decap_4
XFILLER_17_1001 VPWR VGND sg13g2_decap_8
XFILLER_20_921 VPWR VGND sg13g2_decap_8
XFILLER_32_792 VPWR VGND sg13g2_decap_8
XFILLER_20_998 VPWR VGND sg13g2_decap_8
X_2828_ net40 VGND VPWR net433 falutop.alu_inst.op\[2\] clknet_5_23__leaf_clk sg13g2_dfrbpq_2
X_2759_ _0929_ _1145_ _1146_ VPWR VGND sg13g2_nor2_1
XFILLER_48_14 VPWR VGND sg13g2_decap_8
XFILLER_46_339 VPWR VGND sg13g2_fill_1
XFILLER_15_715 VPWR VGND sg13g2_decap_8
XFILLER_14_214 VPWR VGND sg13g2_decap_8
XFILLER_42_589 VPWR VGND sg13g2_decap_4
XFILLER_23_792 VPWR VGND sg13g2_decap_4
XFILLER_10_442 VPWR VGND sg13g2_fill_2
XFILLER_10_431 VPWR VGND sg13g2_decap_8
XFILLER_11_965 VPWR VGND sg13g2_decap_8
XFILLER_7_969 VPWR VGND sg13g2_decap_8
XFILLER_6_468 VPWR VGND sg13g2_decap_8
XFILLER_2_641 VPWR VGND sg13g2_decap_8
XFILLER_1_140 VPWR VGND sg13g2_decap_8
XFILLER_49_155 VPWR VGND sg13g2_decap_8
XFILLER_46_862 VPWR VGND sg13g2_decap_8
Xclkbuf_5_24__f_clk clknet_4_12_0_clk clknet_5_24__leaf_clk VPWR VGND sg13g2_buf_8
XFILLER_45_361 VPWR VGND sg13g2_decap_8
XFILLER_18_564 VPWR VGND sg13g2_decap_8
XFILLER_21_729 VPWR VGND sg13g2_decap_8
XFILLER_33_556 VPWR VGND sg13g2_decap_8
XFILLER_33_589 VPWR VGND sg13g2_decap_8
XFILLER_20_217 VPWR VGND sg13g2_fill_2
X_1992_ _0516_ _0515_ falutop.div_inst.rem\[4\] VPWR VGND sg13g2_nand2b_1
Xclkload10 VPWR clkload10/Y clknet_5_27__leaf_clk VGND sg13g2_inv_1
X_2613_ net328 net368 _1002_ VPWR VGND sg13g2_nor2_1
X_2544_ net308 _0932_ _0933_ VPWR VGND sg13g2_nor2_2
XFILLER_48_0 VPWR VGND sg13g2_decap_8
XFILLER_5_490 VPWR VGND sg13g2_decap_8
X_2475_ _0892_ net232 net374 VPWR VGND sg13g2_nand2b_1
XFILLER_24_534 VPWR VGND sg13g2_decap_8
Xclkload4 VPWR clkload4/Y clknet_5_13__leaf_clk VGND sg13g2_inv_1
XFILLER_3_449 VPWR VGND sg13g2_decap_8
XFILLER_47_604 VPWR VGND sg13g2_decap_4
Xfanout274 _0990_ net274 VPWR VGND sg13g2_buf_8
Xfanout285 net286 net285 VPWR VGND sg13g2_buf_8
Xfanout296 _0861_ net296 VPWR VGND sg13g2_buf_1
XFILLER_28_862 VPWR VGND sg13g2_decap_8
XFILLER_43_843 VPWR VGND sg13g2_decap_8
XFILLER_15_523 VPWR VGND sg13g2_fill_2
XFILLER_42_386 VPWR VGND sg13g2_decap_4
XFILLER_10_250 VPWR VGND sg13g2_decap_8
XFILLER_11_762 VPWR VGND sg13g2_decap_8
XFILLER_7_766 VPWR VGND sg13g2_decap_8
XFILLER_40_70 VPWR VGND sg13g2_decap_8
XFILLER_41_7 VPWR VGND sg13g2_fill_1
X_2260_ falutop.div_inst.i\[1\] net232 net201 _0728_ VPWR VGND sg13g2_nand3_1
X_2191_ VGND VPWR net382 _0670_ _0134_ _0671_ sg13g2_a21oi_1
XFILLER_37_114 VPWR VGND sg13g2_decap_8
XFILLER_1_42 VPWR VGND sg13g2_decap_8
XFILLER_18_383 VPWR VGND sg13g2_decap_4
XFILLER_33_320 VPWR VGND sg13g2_fill_2
XFILLER_34_821 VPWR VGND sg13g2_decap_8
XFILLER_34_876 VPWR VGND sg13g2_decap_8
X_1975_ _0498_ _0485_ _0499_ VPWR VGND sg13g2_nor2b_1
XFILLER_14_1004 VPWR VGND sg13g2_decap_8
XFILLER_20_29 VPWR VGND sg13g2_decap_4
X_2527_ _0916_ net323 net352 VPWR VGND sg13g2_nand2_2
X_2458_ _0879_ _0880_ falutop.i2c_inst.counter\[2\] _0882_ VPWR VGND _0881_ sg13g2_nand4_1
Xhold16 falutop.div_inst.quo\[5\] VPWR VGND net190 sg13g2_dlygate4sd3_1
Xhold27 falutop.div_inst.i\[2\] VPWR VGND net201 sg13g2_dlygate4sd3_1
Xhold38 falutop.div_inst.a\[0\] VPWR VGND net212 sg13g2_dlygate4sd3_1
X_2389_ _0836_ net310 _0834_ VPWR VGND sg13g2_nand2_1
XFILLER_28_114 VPWR VGND sg13g2_fill_1
Xhold49 _0126_ VPWR VGND net223 sg13g2_dlygate4sd3_1
XFILLER_44_618 VPWR VGND sg13g2_decap_8
XFILLER_16_309 VPWR VGND sg13g2_decap_8
XFILLER_43_128 VPWR VGND sg13g2_decap_4
XFILLER_37_692 VPWR VGND sg13g2_decap_8
XFILLER_25_843 VPWR VGND sg13g2_decap_8
XFILLER_12_537 VPWR VGND sg13g2_decap_4
XFILLER_12_559 VPWR VGND sg13g2_decap_8
XFILLER_4_747 VPWR VGND sg13g2_decap_8
XFILLER_3_235 VPWR VGND sg13g2_decap_8
XFILLER_10_73 VPWR VGND sg13g2_decap_8
XFILLER_0_931 VPWR VGND sg13g2_decap_8
XFILLER_48_924 VPWR VGND sg13g2_decap_8
XFILLER_47_456 VPWR VGND sg13g2_fill_2
XFILLER_47_445 VPWR VGND sg13g2_decap_8
XFILLER_19_82 VPWR VGND sg13g2_fill_1
XFILLER_34_128 VPWR VGND sg13g2_decap_8
XFILLER_16_854 VPWR VGND sg13g2_fill_2
XFILLER_37_1026 VPWR VGND sg13g2_fill_2
X_1760_ VGND VPWR _0185_ _0211_ _0289_ _0210_ sg13g2_a21oi_1
XFILLER_7_563 VPWR VGND sg13g2_decap_8
X_1691_ _0221_ _0944_ _0220_ VPWR VGND sg13g2_xnor2_1
X_2312_ _0772_ falutop.div_inst.b1\[0\] falutop.div_inst.acc\[0\] VPWR VGND sg13g2_nand2b_1
X_2243_ _0711_ net250 VPWR VGND sg13g2_inv_2
Xheichips25_template_18 VPWR VGND uio_out[5] sg13g2_tielo
X_2174_ VGND VPWR net382 _0658_ _0129_ _0659_ sg13g2_a21oi_1
XFILLER_39_968 VPWR VGND sg13g2_decap_8
XFILLER_38_423 VPWR VGND sg13g2_decap_8
XFILLER_26_618 VPWR VGND sg13g2_decap_8
XFILLER_19_692 VPWR VGND sg13g2_decap_8
XFILLER_34_651 VPWR VGND sg13g2_decap_8
XFILLER_21_312 VPWR VGND sg13g2_fill_2
XFILLER_22_813 VPWR VGND sg13g2_fill_2
XFILLER_34_695 VPWR VGND sg13g2_decap_8
XFILLER_22_857 VPWR VGND sg13g2_decap_8
X_1958_ _0443_ VPWR _0482_ VGND _0263_ _0442_ sg13g2_o21ai_1
XFILLER_31_39 VPWR VGND sg13g2_fill_2
X_1889_ _0415_ _0396_ _0414_ VPWR VGND sg13g2_xnor2_1
XFILLER_1_728 VPWR VGND sg13g2_decap_8
XFILLER_0_238 VPWR VGND sg13g2_decap_8
XFILLER_45_938 VPWR VGND sg13g2_decap_8
XFILLER_29_489 VPWR VGND sg13g2_decap_8
XFILLER_16_117 VPWR VGND sg13g2_fill_2
XFILLER_13_824 VPWR VGND sg13g2_decap_8
XFILLER_9_817 VPWR VGND sg13g2_decap_8
XFILLER_12_323 VPWR VGND sg13g2_fill_2
XFILLER_12_334 VPWR VGND sg13g2_fill_2
XFILLER_8_338 VPWR VGND sg13g2_decap_4
XFILLER_21_890 VPWR VGND sg13g2_decap_8
XFILLER_4_544 VPWR VGND sg13g2_decap_8
X_2857__140 VPWR VGND net140 sg13g2_tiehi
XFILLER_48_710 VPWR VGND sg13g2_fill_1
XFILLER_36_927 VPWR VGND sg13g2_decap_8
XFILLER_48_798 VPWR VGND sg13g2_decap_8
XFILLER_47_297 VPWR VGND sg13g2_decap_8
XFILLER_44_993 VPWR VGND sg13g2_decap_8
XFILLER_43_470 VPWR VGND sg13g2_decap_8
XFILLER_15_150 VPWR VGND sg13g2_decap_8
XFILLER_15_194 VPWR VGND sg13g2_fill_1
X_2861_ net132 VGND VPWR _0082_ falutop.i2c_inst.result\[3\] clknet_5_22__leaf_clk
+ sg13g2_dfrbpq_1
XFILLER_30_153 VPWR VGND sg13g2_decap_8
X_2792_ net88 VGND VPWR net267 falutop.div_inst.acc\[6\] clknet_5_2__leaf_clk sg13g2_dfrbpq_2
XFILLER_30_197 VPWR VGND sg13g2_decap_4
X_1812_ net282 VPWR _0340_ VGND net368 _0976_ sg13g2_o21ai_1
XFILLER_7_63 VPWR VGND sg13g2_decap_8
XFILLER_11_1007 VPWR VGND sg13g2_decap_8
X_1743_ net335 net350 _0272_ VPWR VGND sg13g2_and2_1
XFILLER_8_894 VPWR VGND sg13g2_decap_8
X_1674_ _0204_ _0924_ _0202_ VPWR VGND sg13g2_xnor2_1
X_2226_ net393 VPWR _0696_ VGND net264 _0695_ sg13g2_o21ai_1
XFILLER_39_765 VPWR VGND sg13g2_decap_8
XFILLER_38_264 VPWR VGND sg13g2_fill_1
X_2892__33 VPWR VGND net33 sg13g2_tiehi
XFILLER_26_426 VPWR VGND sg13g2_decap_8
X_2157_ _0604_ net373 _0647_ VPWR VGND sg13g2_nor2b_1
XFILLER_42_919 VPWR VGND sg13g2_decap_8
X_2088_ _0607_ _0606_ net373 net289 net479 VPWR VGND sg13g2_a22oi_1
XFILLER_22_643 VPWR VGND sg13g2_decap_8
XFILLER_10_816 VPWR VGND sg13g2_decap_8
XFILLER_21_175 VPWR VGND sg13g2_decap_8
X_2801__74 VPWR VGND net74 sg13g2_tiehi
XFILLER_1_525 VPWR VGND sg13g2_decap_8
Xclkbuf_5_5__f_clk clknet_4_2_0_clk clknet_5_5__leaf_clk VPWR VGND sg13g2_buf_8
XFILLER_18_905 VPWR VGND sg13g2_decap_8
XFILLER_29_253 VPWR VGND sg13g2_decap_8
XFILLER_17_437 VPWR VGND sg13g2_decap_8
XFILLER_45_768 VPWR VGND sg13g2_decap_8
XFILLER_16_61 VPWR VGND sg13g2_fill_2
XFILLER_26_993 VPWR VGND sg13g2_decap_8
XFILLER_16_94 VPWR VGND sg13g2_decap_8
XFILLER_41_963 VPWR VGND sg13g2_decap_8
XFILLER_9_614 VPWR VGND sg13g2_decap_8
XFILLER_13_654 VPWR VGND sg13g2_decap_8
XFILLER_13_676 VPWR VGND sg13g2_decap_4
XFILLER_5_875 VPWR VGND sg13g2_decap_8
X_2011_ _0532_ _0524_ _0534_ VPWR VGND sg13g2_xor2_1
XFILLER_48_551 VPWR VGND sg13g2_decap_8
XFILLER_35_212 VPWR VGND sg13g2_decap_4
XFILLER_24_919 VPWR VGND sg13g2_decap_8
XFILLER_16_492 VPWR VGND sg13g2_fill_1
XFILLER_32_930 VPWR VGND sg13g2_decap_8
X_2913_ net115 VGND VPWR _0134_ falutop.i2c_inst.data_in\[6\] clknet_5_10__leaf_clk
+ sg13g2_dfrbpq_1
X_2844_ net166 VGND VPWR net209 falutop.div_inst.val\[2\] clknet_5_20__leaf_clk sg13g2_dfrbpq_2
XFILLER_12_19 VPWR VGND sg13g2_decap_8
XFILLER_8_691 VPWR VGND sg13g2_decap_8
X_2775_ _1161_ net362 net339 net364 net336 VPWR VGND sg13g2_a22oi_1
Xhold135 falutop.i2c_inst.counter\[3\] VPWR VGND net436 sg13g2_dlygate4sd3_1
Xhold102 _0050_ VPWR VGND net403 sg13g2_dlygate4sd3_1
X_1726_ VPWR VGND _0940_ _0253_ _1016_ _0939_ _0255_ _1008_ sg13g2_a221oi_1
Xhold124 falutop.div_inst.b\[5\] VPWR VGND net425 sg13g2_dlygate4sd3_1
Xhold113 falutop.div_inst.b\[4\] VPWR VGND net414 sg13g2_dlygate4sd3_1
Xhold168 falutop.i2c_inst.result\[1\] VPWR VGND net469 sg13g2_dlygate4sd3_1
Xhold157 falutop.div_inst.b1\[2\] VPWR VGND net458 sg13g2_dlygate4sd3_1
Xhold146 falutop.div_inst.b1\[1\] VPWR VGND net447 sg13g2_dlygate4sd3_1
X_1657_ _1285_ _1287_ _0187_ VPWR VGND sg13g2_nor2b_1
X_1588_ _1283_ VPWR _1288_ VGND _1285_ _1286_ sg13g2_o21ai_1
Xhold179 _0607_ VPWR VGND net480 sg13g2_dlygate4sd3_1
XFILLER_39_562 VPWR VGND sg13g2_decap_8
XFILLER_37_16 VPWR VGND sg13g2_decap_8
XFILLER_2_1005 VPWR VGND sg13g2_decap_8
X_2209_ _0684_ net379 net437 VPWR VGND sg13g2_nand2_2
XFILLER_39_595 VPWR VGND sg13g2_decap_8
XFILLER_15_908 VPWR VGND sg13g2_decap_8
XFILLER_27_768 VPWR VGND sg13g2_decap_8
XFILLER_27_779 VPWR VGND sg13g2_fill_1
XFILLER_35_790 VPWR VGND sg13g2_decap_8
XFILLER_23_974 VPWR VGND sg13g2_decap_8
XFILLER_22_473 VPWR VGND sg13g2_fill_2
XFILLER_5_127 VPWR VGND sg13g2_fill_1
XFILLER_2_823 VPWR VGND sg13g2_decap_8
XFILLER_1_322 VPWR VGND sg13g2_decap_8
XFILLER_1_399 VPWR VGND sg13g2_decap_8
XFILLER_17_212 VPWR VGND sg13g2_fill_1
XFILLER_17_245 VPWR VGND sg13g2_decap_8
XFILLER_17_256 VPWR VGND sg13g2_fill_2
XFILLER_14_941 VPWR VGND sg13g2_decap_8
XFILLER_32_237 VPWR VGND sg13g2_decap_8
XFILLER_13_440 VPWR VGND sg13g2_decap_4
XFILLER_43_70 VPWR VGND sg13g2_decap_8
XFILLER_9_455 VPWR VGND sg13g2_decap_8
Xheichips25_template_5 VPWR VGND uio_oe[0] sg13g2_tielo
X_2560_ _0947_ _0937_ _0949_ VPWR VGND sg13g2_xor2_1
XFILLER_5_672 VPWR VGND sg13g2_decap_8
X_2491_ net460 falutop.div_inst.b\[7\] _0736_ _0061_ VPWR VGND sg13g2_mux2_1
X_1511_ net390 VPWR _1213_ VGND net484 net294 sg13g2_o21ai_1
XFILLER_4_193 VPWR VGND sg13g2_decap_4
XFILLER_4_53 VPWR VGND sg13g2_decap_8
XFILLER_49_860 VPWR VGND sg13g2_decap_8
XFILLER_36_532 VPWR VGND sg13g2_decap_8
XFILLER_36_576 VPWR VGND sg13g2_decap_8
XFILLER_20_900 VPWR VGND sg13g2_decap_8
XFILLER_23_259 VPWR VGND sg13g2_decap_8
XFILLER_32_760 VPWR VGND sg13g2_decap_8
XFILLER_23_29 VPWR VGND sg13g2_decap_4
XFILLER_20_977 VPWR VGND sg13g2_decap_8
XFILLER_31_281 VPWR VGND sg13g2_decap_8
XFILLER_31_292 VPWR VGND sg13g2_fill_1
X_2827_ net41 VGND VPWR _0048_ falutop.alu_inst.op\[1\] clknet_5_31__leaf_clk sg13g2_dfrbpq_2
X_2758_ VGND VPWR _0928_ _1014_ _1145_ _1012_ sg13g2_a21oi_1
X_1709_ net392 VPWR _0238_ VGND net475 net293 sg13g2_o21ai_1
X_2689_ _1077_ _1073_ _1076_ VPWR VGND sg13g2_xnor2_1
XFILLER_24_1017 VPWR VGND sg13g2_decap_8
XFILLER_47_819 VPWR VGND sg13g2_decap_8
XFILLER_24_1028 VPWR VGND sg13g2_fill_1
XFILLER_27_532 VPWR VGND sg13g2_decap_8
XFILLER_15_749 VPWR VGND sg13g2_decap_8
XFILLER_42_568 VPWR VGND sg13g2_decap_8
XFILLER_30_719 VPWR VGND sg13g2_decap_8
XFILLER_23_771 VPWR VGND sg13g2_decap_8
XFILLER_11_944 VPWR VGND sg13g2_decap_8
XFILLER_10_487 VPWR VGND sg13g2_decap_4
XFILLER_7_948 VPWR VGND sg13g2_decap_8
XFILLER_6_447 VPWR VGND sg13g2_decap_8
XFILLER_2_620 VPWR VGND sg13g2_decap_8
XFILLER_2_697 VPWR VGND sg13g2_decap_8
XFILLER_29_9 VPWR VGND sg13g2_fill_2
XFILLER_1_196 VPWR VGND sg13g2_decap_8
XFILLER_46_841 VPWR VGND sg13g2_decap_8
XFILLER_18_587 VPWR VGND sg13g2_decap_8
XFILLER_33_513 VPWR VGND sg13g2_decap_8
XFILLER_33_535 VPWR VGND sg13g2_decap_8
XFILLER_33_579 VPWR VGND sg13g2_fill_1
XFILLER_14_782 VPWR VGND sg13g2_decap_4
X_1991_ net371 VPWR _0515_ VGND falutop.div_inst.rem\[3\] _0432_ sg13g2_o21ai_1
XFILLER_9_241 VPWR VGND sg13g2_fill_2
XFILLER_13_281 VPWR VGND sg13g2_fill_1
Xclkload11 VPWR clkload11/Y clknet_5_29__leaf_clk VGND sg13g2_inv_1
X_2612_ _0978_ _1000_ _1001_ VPWR VGND sg13g2_nor2_2
X_2543_ net341 net366 _0932_ VPWR VGND sg13g2_nor2_2
X_2474_ net232 falutop.div_inst.busy _0891_ VPWR VGND sg13g2_and2_1
XFILLER_29_808 VPWR VGND sg13g2_decap_8
XFILLER_29_819 VPWR VGND sg13g2_decap_8
XFILLER_37_852 VPWR VGND sg13g2_decap_8
Xclkload5 VPWR clkload5/Y clknet_5_15__leaf_clk VGND sg13g2_inv_1
XFILLER_20_785 VPWR VGND sg13g2_decap_8
XFILLER_4_929 VPWR VGND sg13g2_decap_8
Xclkbuf_5_30__f_clk clknet_4_15_0_clk clknet_5_30__leaf_clk VPWR VGND sg13g2_buf_8
XFILLER_3_428 VPWR VGND sg13g2_decap_8
XFILLER_1_7 VPWR VGND sg13g2_decap_8
Xfanout297 _0842_ net297 VPWR VGND sg13g2_buf_8
Xfanout275 net276 net275 VPWR VGND sg13g2_buf_8
Xfanout286 net287 net286 VPWR VGND sg13g2_buf_8
XFILLER_28_841 VPWR VGND sg13g2_decap_8
XFILLER_46_159 VPWR VGND sg13g2_decap_8
XFILLER_15_502 VPWR VGND sg13g2_decap_8
XFILLER_43_822 VPWR VGND sg13g2_decap_8
XFILLER_43_899 VPWR VGND sg13g2_decap_8
XFILLER_24_50 VPWR VGND sg13g2_fill_2
XFILLER_11_741 VPWR VGND sg13g2_decap_8
XFILLER_7_745 VPWR VGND sg13g2_decap_8
XFILLER_40_93 VPWR VGND sg13g2_decap_8
XFILLER_6_288 VPWR VGND sg13g2_decap_8
XFILLER_3_995 VPWR VGND sg13g2_decap_8
X_2190_ net386 VPWR _0671_ VGND net423 _0670_ sg13g2_o21ai_1
XFILLER_38_605 VPWR VGND sg13g2_decap_8
XFILLER_2_494 VPWR VGND sg13g2_decap_8
XFILLER_1_21 VPWR VGND sg13g2_decap_8
XFILLER_1_98 VPWR VGND sg13g2_decap_8
XFILLER_46_693 VPWR VGND sg13g2_decap_8
X_2867__120 VPWR VGND net120 sg13g2_tiehi
XFILLER_33_354 VPWR VGND sg13g2_decap_8
XFILLER_34_855 VPWR VGND sg13g2_decap_8
X_1974_ _0498_ _0490_ _0497_ VPWR VGND sg13g2_xnor2_1
X_2526_ net326 net352 _0915_ VPWR VGND sg13g2_and2_1
X_2457_ _0881_ _0845_ falutop.i2c_inst.result\[14\] _0828_ falutop.i2c_inst.result\[12\]
+ VPWR VGND sg13g2_a22oi_1
Xhold17 _0004_ VPWR VGND net191 sg13g2_dlygate4sd3_1
Xhold28 _0053_ VPWR VGND net202 sg13g2_dlygate4sd3_1
XFILLER_29_39 VPWR VGND sg13g2_fill_2
X_2388_ _0835_ _0709_ _0833_ VPWR VGND sg13g2_nand2_2
Xhold39 _0741_ VPWR VGND net213 sg13g2_dlygate4sd3_1
XFILLER_21_1009 VPWR VGND sg13g2_decap_8
XFILLER_25_822 VPWR VGND sg13g2_decap_8
XFILLER_12_516 VPWR VGND sg13g2_decap_8
XFILLER_4_726 VPWR VGND sg13g2_decap_8
XFILLER_3_214 VPWR VGND sg13g2_decap_8
XFILLER_0_910 VPWR VGND sg13g2_decap_8
XFILLER_48_903 VPWR VGND sg13g2_decap_8
XFILLER_0_987 VPWR VGND sg13g2_decap_8
XFILLER_47_479 VPWR VGND sg13g2_decap_4
XFILLER_19_159 VPWR VGND sg13g2_fill_2
XFILLER_16_811 VPWR VGND sg13g2_decap_8
XFILLER_16_833 VPWR VGND sg13g2_decap_8
XFILLER_34_107 VPWR VGND sg13g2_decap_8
XFILLER_37_1005 VPWR VGND sg13g2_decap_8
XFILLER_43_685 VPWR VGND sg13g2_decap_8
XFILLER_30_324 VPWR VGND sg13g2_decap_8
XFILLER_30_346 VPWR VGND sg13g2_decap_8
XFILLER_31_858 VPWR VGND sg13g2_fill_2
XFILLER_30_379 VPWR VGND sg13g2_decap_4
XFILLER_7_542 VPWR VGND sg13g2_decap_8
X_1690_ _0915_ _0156_ _0220_ VPWR VGND sg13g2_nor2_1
X_2311_ falutop.div_inst.b1\[1\] falutop.div_inst.acc\[1\] _0771_ VPWR VGND sg13g2_nor2b_1
XFILLER_3_792 VPWR VGND sg13g2_decap_8
XFILLER_2_291 VPWR VGND sg13g2_decap_8
XFILLER_32_4 VPWR VGND sg13g2_decap_8
X_2242_ VPWR _0710_ net176 VGND sg13g2_inv_1
Xheichips25_template_19 VPWR VGND uio_out[6] sg13g2_tielo
X_2173_ net386 VPWR _0659_ VGND net246 _0658_ sg13g2_o21ai_1
XFILLER_39_947 VPWR VGND sg13g2_decap_8
XFILLER_47_980 VPWR VGND sg13g2_decap_8
XFILLER_19_671 VPWR VGND sg13g2_decap_8
XFILLER_34_674 VPWR VGND sg13g2_decap_8
XFILLER_21_368 VPWR VGND sg13g2_decap_8
XFILLER_21_379 VPWR VGND sg13g2_fill_1
X_1957_ VGND VPWR _0440_ _0457_ _0481_ _0456_ sg13g2_a21oi_1
X_1888_ _0412_ _0397_ _0414_ VPWR VGND sg13g2_xor2_1
XFILLER_1_707 VPWR VGND sg13g2_decap_8
X_2509_ VGND VPWR _0701_ net300 _0070_ _0906_ sg13g2_a21oi_1
XFILLER_0_217 VPWR VGND sg13g2_decap_8
XFILLER_45_917 VPWR VGND sg13g2_decap_8
XFILLER_17_608 VPWR VGND sg13g2_decap_8
XFILLER_29_468 VPWR VGND sg13g2_decap_8
XFILLER_44_416 VPWR VGND sg13g2_decap_8
XFILLER_38_980 VPWR VGND sg13g2_decap_8
XFILLER_40_611 VPWR VGND sg13g2_decap_8
XFILLER_13_803 VPWR VGND sg13g2_decap_8
XFILLER_24_151 VPWR VGND sg13g2_decap_4
XFILLER_25_674 VPWR VGND sg13g2_decap_8
XFILLER_40_699 VPWR VGND sg13g2_decap_8
XFILLER_4_523 VPWR VGND sg13g2_decap_8
XFILLER_0_784 VPWR VGND sg13g2_decap_8
XFILLER_48_777 VPWR VGND sg13g2_decap_8
XFILLER_36_906 VPWR VGND sg13g2_decap_8
XFILLER_47_276 VPWR VGND sg13g2_decap_4
XFILLER_46_92 VPWR VGND sg13g2_decap_8
XFILLER_44_972 VPWR VGND sg13g2_decap_8
XFILLER_43_460 VPWR VGND sg13g2_fill_1
X_2860_ net134 VGND VPWR net487 falutop.i2c_inst.result\[2\] clknet_5_22__leaf_clk
+ sg13g2_dfrbpq_1
XFILLER_30_143 VPWR VGND sg13g2_fill_1
X_1811_ _0339_ _0251_ _0973_ _0247_ _0939_ VPWR VGND sg13g2_a22oi_1
XFILLER_31_677 VPWR VGND sg13g2_decap_8
X_2791_ net90 VGND VPWR net263 falutop.div_inst.acc\[5\] clknet_5_2__leaf_clk sg13g2_dfrbpq_2
XFILLER_8_873 VPWR VGND sg13g2_decap_8
XFILLER_7_42 VPWR VGND sg13g2_decap_8
X_1742_ _0271_ net332 net355 VPWR VGND sg13g2_nand2_1
XFILLER_7_372 VPWR VGND sg13g2_fill_1
X_1673_ net350 _0924_ net345 _0203_ VPWR VGND sg13g2_nand3_1
X_2225_ _0652_ _0657_ _0695_ VPWR VGND sg13g2_nor2_1
XFILLER_39_799 VPWR VGND sg13g2_fill_2
XFILLER_26_18 VPWR VGND sg13g2_decap_8
XFILLER_27_939 VPWR VGND sg13g2_decap_8
X_2156_ net425 net291 _0646_ VPWR VGND sg13g2_nor2_1
X_2087_ falutop.data_in\[6\] net289 _0605_ _0606_ VPWR VGND sg13g2_nor3_1
XFILLER_35_983 VPWR VGND sg13g2_decap_8
XFILLER_22_622 VPWR VGND sg13g2_decap_8
XFILLER_5_309 VPWR VGND sg13g2_decap_8
XFILLER_1_504 VPWR VGND sg13g2_decap_8
XFILLER_29_232 VPWR VGND sg13g2_decap_8
XFILLER_17_405 VPWR VGND sg13g2_decap_8
XFILLER_45_747 VPWR VGND sg13g2_decap_8
XFILLER_44_257 VPWR VGND sg13g2_decap_4
XFILLER_26_972 VPWR VGND sg13g2_decap_8
XFILLER_41_942 VPWR VGND sg13g2_decap_8
XFILLER_16_73 VPWR VGND sg13g2_decap_8
XFILLER_25_482 VPWR VGND sg13g2_fill_2
XFILLER_25_493 VPWR VGND sg13g2_decap_8
XFILLER_8_103 VPWR VGND sg13g2_decap_8
XFILLER_32_83 VPWR VGND sg13g2_decap_8
XFILLER_5_854 VPWR VGND sg13g2_decap_8
XFILLER_4_397 VPWR VGND sg13g2_decap_8
XFILLER_0_581 VPWR VGND sg13g2_decap_8
X_2010_ _0533_ _0524_ _0532_ VPWR VGND sg13g2_nand2b_1
XFILLER_48_563 VPWR VGND sg13g2_decap_8
XFILLER_48_574 VPWR VGND sg13g2_fill_1
XFILLER_35_202 VPWR VGND sg13g2_fill_1
XFILLER_36_747 VPWR VGND sg13g2_decap_8
XFILLER_35_257 VPWR VGND sg13g2_decap_8
X_2912_ net119 VGND VPWR _0133_ falutop.i2c_inst.data_in\[5\] clknet_5_10__leaf_clk
+ sg13g2_dfrbpq_1
XFILLER_17_994 VPWR VGND sg13g2_decap_8
XFILLER_32_986 VPWR VGND sg13g2_decap_8
X_2843_ net168 VGND VPWR net407 falutop.div_inst.val\[1\] clknet_5_17__leaf_clk sg13g2_dfrbpq_2
X_2774_ VGND VPWR _0717_ net273 _1160_ _1159_ sg13g2_a21oi_1
XFILLER_8_670 VPWR VGND sg13g2_decap_8
X_1725_ falutop.alu_inst.op\[2\] _0940_ _0977_ _0254_ VPWR VGND sg13g2_nor3_1
Xhold103 falutop.i2c_inst.data_in\[2\] VPWR VGND net404 sg13g2_dlygate4sd3_1
Xhold125 _0125_ VPWR VGND net426 sg13g2_dlygate4sd3_1
Xhold114 _0124_ VPWR VGND net415 sg13g2_dlygate4sd3_1
Xhold136 _0674_ VPWR VGND net437 sg13g2_dlygate4sd3_1
Xhold147 falutop.i2c_inst.data_in\[13\] VPWR VGND net448 sg13g2_dlygate4sd3_1
Xhold158 falutop.div_inst.b1\[6\] VPWR VGND net459 sg13g2_dlygate4sd3_1
X_1656_ _1292_ _1294_ _0186_ VPWR VGND sg13g2_and2_1
Xhold169 _0080_ VPWR VGND net470 sg13g2_dlygate4sd3_1
X_1587_ _1283_ _1285_ _1286_ _1287_ VPWR VGND sg13g2_or3_1
XFILLER_39_541 VPWR VGND sg13g2_decap_8
X_2208_ VGND VPWR net383 _0682_ _0139_ _0683_ sg13g2_a21oi_1
XFILLER_2_1028 VPWR VGND sg13g2_fill_1
X_2139_ net450 net207 net291 _0120_ VPWR VGND sg13g2_mux2_1
XFILLER_42_728 VPWR VGND sg13g2_decap_8
XFILLER_41_205 VPWR VGND sg13g2_decap_8
XFILLER_26_257 VPWR VGND sg13g2_decap_8
XFILLER_23_953 VPWR VGND sg13g2_decap_8
XFILLER_6_629 VPWR VGND sg13g2_decap_8
XFILLER_2_802 VPWR VGND sg13g2_decap_8
XFILLER_1_301 VPWR VGND sg13g2_decap_8
XFILLER_2_879 VPWR VGND sg13g2_decap_8
XFILLER_49_338 VPWR VGND sg13g2_decap_4
XFILLER_1_378 VPWR VGND sg13g2_decap_8
XFILLER_17_202 VPWR VGND sg13g2_fill_2
XFILLER_45_555 VPWR VGND sg13g2_decap_8
XFILLER_27_72 VPWR VGND sg13g2_decap_8
XFILLER_14_920 VPWR VGND sg13g2_decap_8
XFILLER_9_412 VPWR VGND sg13g2_fill_1
XFILLER_13_474 VPWR VGND sg13g2_fill_1
XFILLER_14_997 VPWR VGND sg13g2_decap_8
XFILLER_40_282 VPWR VGND sg13g2_decap_8
XFILLER_9_467 VPWR VGND sg13g2_decap_8
Xheichips25_template_6 VPWR VGND uio_oe[1] sg13g2_tielo
XFILLER_5_651 VPWR VGND sg13g2_decap_8
X_2490_ net459 net222 _0736_ _0060_ VPWR VGND sg13g2_mux2_1
X_2792__88 VPWR VGND net88 sg13g2_tiehi
X_1510_ VPWR VGND net304 net295 _1211_ net278 _1212_ _1209_ sg13g2_a221oi_1
XFILLER_4_172 VPWR VGND sg13g2_decap_8
XFILLER_4_32 VPWR VGND sg13g2_decap_8
XFILLER_23_238 VPWR VGND sg13g2_decap_8
XFILLER_24_739 VPWR VGND sg13g2_decap_8
XFILLER_16_290 VPWR VGND sg13g2_decap_4
XFILLER_31_260 VPWR VGND sg13g2_decap_8
X_2826_ net42 VGND VPWR net251 falutop.alu_inst.op\[0\] clknet_5_29__leaf_clk sg13g2_dfrbpq_2
XFILLER_20_956 VPWR VGND sg13g2_decap_8
X_2757_ VGND VPWR _0927_ _1016_ _1144_ _1138_ sg13g2_a21oi_1
XFILLER_2_109 VPWR VGND sg13g2_decap_8
X_2688_ _1076_ _1074_ _1075_ VPWR VGND sg13g2_nand2_1
X_1708_ _0236_ _0237_ _0085_ VPWR VGND sg13g2_nor2_1
X_1639_ VPWR VGND _0169_ net295 _0168_ net278 _0170_ _0165_ sg13g2_a221oi_1
XFILLER_48_49 VPWR VGND sg13g2_decap_8
XFILLER_46_319 VPWR VGND sg13g2_decap_8
XFILLER_27_500 VPWR VGND sg13g2_decap_8
XFILLER_42_547 VPWR VGND sg13g2_decap_8
XFILLER_42_536 VPWR VGND sg13g2_decap_8
XFILLER_27_599 VPWR VGND sg13g2_decap_8
XFILLER_11_923 VPWR VGND sg13g2_decap_8
XFILLER_10_422 VPWR VGND sg13g2_decap_4
XFILLER_22_282 VPWR VGND sg13g2_decap_8
XFILLER_22_293 VPWR VGND sg13g2_fill_1
XFILLER_7_927 VPWR VGND sg13g2_decap_8
XFILLER_2_676 VPWR VGND sg13g2_decap_8
X_2916__93 VPWR VGND net93 sg13g2_tiehi
XFILLER_49_102 VPWR VGND sg13g2_fill_1
XFILLER_1_175 VPWR VGND sg13g2_decap_8
XFILLER_49_135 VPWR VGND sg13g2_decap_8
XFILLER_46_820 VPWR VGND sg13g2_decap_8
XFILLER_18_533 VPWR VGND sg13g2_decap_8
XFILLER_18_544 VPWR VGND sg13g2_fill_2
XFILLER_46_897 VPWR VGND sg13g2_decap_8
XFILLER_21_709 VPWR VGND sg13g2_decap_8
X_1990_ net279 VPWR _0514_ VGND _0510_ _0513_ sg13g2_o21ai_1
XFILLER_9_220 VPWR VGND sg13g2_decap_8
XFILLER_9_286 VPWR VGND sg13g2_decap_8
Xclkload12 VPWR clkload12/Y clknet_5_31__leaf_clk VGND sg13g2_inv_1
X_2611_ _1000_ falutop.alu_inst.op\[0\] VPWR VGND falutop.alu_inst.op\[1\] sg13g2_nand2b_2
X_2542_ _0931_ net339 net364 VPWR VGND sg13g2_nand2_1
XFILLER_6_993 VPWR VGND sg13g2_decap_8
X_2473_ _0050_ _0723_ net285 net392 _0712_ VPWR VGND sg13g2_a22oi_1
XFILLER_37_886 VPWR VGND sg13g2_decap_8
XFILLER_32_580 VPWR VGND sg13g2_fill_2
XFILLER_20_764 VPWR VGND sg13g2_decap_8
Xclkload6 VPWR clkload6/Y clknet_5_19__leaf_clk VGND sg13g2_inv_1
X_2809_ net61 VGND VPWR net405 falutop.data_in\[2\] clknet_5_14__leaf_clk sg13g2_dfrbpq_2
XFILLER_4_908 VPWR VGND sg13g2_decap_8
XFILLER_20_797 VPWR VGND sg13g2_decap_8
XFILLER_30_1022 VPWR VGND sg13g2_decap_8
XFILLER_3_407 VPWR VGND sg13g2_decap_8
XFILLER_47_628 VPWR VGND sg13g2_decap_8
Xfanout276 _0739_ net276 VPWR VGND sg13g2_buf_8
Xfanout298 net299 net298 VPWR VGND sg13g2_buf_8
Xfanout287 net288 net287 VPWR VGND sg13g2_buf_8
XFILLER_43_801 VPWR VGND sg13g2_decap_8
XFILLER_27_374 VPWR VGND sg13g2_decap_8
XFILLER_43_878 VPWR VGND sg13g2_decap_8
XFILLER_15_547 VPWR VGND sg13g2_decap_8
XFILLER_30_506 VPWR VGND sg13g2_decap_8
XFILLER_11_720 VPWR VGND sg13g2_decap_8
XFILLER_7_724 VPWR VGND sg13g2_decap_8
XFILLER_6_234 VPWR VGND sg13g2_decap_8
XFILLER_11_797 VPWR VGND sg13g2_decap_8
XFILLER_3_974 VPWR VGND sg13g2_decap_8
XFILLER_2_473 VPWR VGND sg13g2_decap_8
XFILLER_49_81 VPWR VGND sg13g2_decap_8
XFILLER_27_7 VPWR VGND sg13g2_decap_8
XFILLER_19_842 VPWR VGND sg13g2_decap_4
XFILLER_1_77 VPWR VGND sg13g2_decap_8
XFILLER_18_330 VPWR VGND sg13g2_decap_8
XFILLER_34_801 VPWR VGND sg13g2_decap_8
XFILLER_19_886 VPWR VGND sg13g2_decap_8
XFILLER_34_812 VPWR VGND sg13g2_fill_2
X_1973_ _0497_ _0491_ _0495_ VPWR VGND sg13g2_xnor2_1
XFILLER_14_580 VPWR VGND sg13g2_decap_8
XFILLER_21_539 VPWR VGND sg13g2_decap_8
XFILLER_6_790 VPWR VGND sg13g2_decap_8
X_2525_ VGND VPWR _0816_ net300 _0078_ _0914_ sg13g2_a21oi_1
X_2456_ falutop.i2c_inst.counter\[1\] falutop.i2c_inst.counter\[0\] falutop.i2c_inst.result\[15\]
+ _0880_ VPWR VGND sg13g2_nand3_1
Xhold29 falutop.div_inst.val\[7\] VPWR VGND net203 sg13g2_dlygate4sd3_1
Xhold18 falutop.div_inst.acc_next\[0\] VPWR VGND net192 sg13g2_dlygate4sd3_1
X_2387_ net434 net436 net379 _0834_ VPWR VGND sg13g2_nor3_1
XFILLER_29_639 VPWR VGND sg13g2_decap_8
XFILLER_28_149 VPWR VGND sg13g2_decap_4
XFILLER_24_333 VPWR VGND sg13g2_decap_4
XFILLER_25_878 VPWR VGND sg13g2_decap_8
XFILLER_36_182 VPWR VGND sg13g2_decap_8
XFILLER_40_826 VPWR VGND sg13g2_decap_8
XFILLER_24_377 VPWR VGND sg13g2_decap_8
XFILLER_20_594 VPWR VGND sg13g2_fill_1
XFILLER_4_705 VPWR VGND sg13g2_decap_8
XFILLER_10_53 VPWR VGND sg13g2_decap_8
XFILLER_0_966 VPWR VGND sg13g2_decap_8
XFILLER_48_959 VPWR VGND sg13g2_decap_8
XFILLER_19_73 VPWR VGND sg13g2_decap_8
XFILLER_28_672 VPWR VGND sg13g2_decap_8
XFILLER_43_642 VPWR VGND sg13g2_decap_8
XFILLER_15_344 VPWR VGND sg13g2_decap_8
XFILLER_35_50 VPWR VGND sg13g2_fill_2
XFILLER_43_664 VPWR VGND sg13g2_decap_8
XFILLER_42_163 VPWR VGND sg13g2_fill_2
XFILLER_37_1028 VPWR VGND sg13g2_fill_1
XFILLER_16_889 VPWR VGND sg13g2_decap_8
XFILLER_30_303 VPWR VGND sg13g2_decap_8
XFILLER_31_804 VPWR VGND sg13g2_fill_2
XFILLER_35_83 VPWR VGND sg13g2_decap_8
XFILLER_42_174 VPWR VGND sg13g2_decap_8
XFILLER_15_399 VPWR VGND sg13g2_decap_4
XFILLER_31_837 VPWR VGND sg13g2_decap_8
XFILLER_7_521 VPWR VGND sg13g2_decap_8
XFILLER_11_583 VPWR VGND sg13g2_decap_8
XFILLER_7_598 VPWR VGND sg13g2_decap_8
XFILLER_3_771 VPWR VGND sg13g2_decap_8
X_2310_ _0770_ falutop.div_inst.acc\[2\] falutop.div_inst.b1\[2\] VPWR VGND sg13g2_nand2b_1
X_2241_ _0709_ net379 VPWR VGND sg13g2_inv_2
XFILLER_2_270 VPWR VGND sg13g2_decap_8
XFILLER_39_926 VPWR VGND sg13g2_decap_8
XFILLER_25_4 VPWR VGND sg13g2_decap_8
X_2172_ _0835_ _0657_ _0658_ VPWR VGND sg13g2_nor2_1
XFILLER_38_447 VPWR VGND sg13g2_decap_8
XFILLER_25_108 VPWR VGND sg13g2_fill_1
XFILLER_25_119 VPWR VGND sg13g2_fill_2
XFILLER_22_826 VPWR VGND sg13g2_decap_8
XFILLER_33_141 VPWR VGND sg13g2_decap_8
XFILLER_21_314 VPWR VGND sg13g2_fill_1
XFILLER_21_336 VPWR VGND sg13g2_decap_4
XFILLER_33_174 VPWR VGND sg13g2_decap_8
X_1956_ _0460_ VPWR _0480_ VGND _0437_ _0458_ sg13g2_o21ai_1
X_1887_ _0397_ _0412_ _0413_ VPWR VGND sg13g2_nor2_1
X_2508_ net389 VPWR _0906_ VGND net203 net301 sg13g2_o21ai_1
X_2439_ net448 falutop.data_in\[13\] net312 _0041_ VPWR VGND sg13g2_mux2_1
XFILLER_5_1015 VPWR VGND sg13g2_decap_8
XFILLER_29_447 VPWR VGND sg13g2_decap_8
XFILLER_44_439 VPWR VGND sg13g2_decap_8
XFILLER_25_620 VPWR VGND sg13g2_decap_8
XFILLER_25_653 VPWR VGND sg13g2_decap_8
XFILLER_24_130 VPWR VGND sg13g2_decap_8
XFILLER_12_336 VPWR VGND sg13g2_fill_1
XFILLER_13_859 VPWR VGND sg13g2_decap_8
XFILLER_40_667 VPWR VGND sg13g2_decap_8
XFILLER_8_329 VPWR VGND sg13g2_decap_4
XFILLER_4_502 VPWR VGND sg13g2_decap_8
XFILLER_21_41 VPWR VGND sg13g2_decap_8
XFILLER_21_85 VPWR VGND sg13g2_decap_8
XFILLER_4_579 VPWR VGND sg13g2_decap_8
XFILLER_48_701 VPWR VGND sg13g2_decap_8
XFILLER_0_763 VPWR VGND sg13g2_decap_8
XFILLER_47_222 VPWR VGND sg13g2_decap_8
XFILLER_48_756 VPWR VGND sg13g2_decap_8
XFILLER_29_981 VPWR VGND sg13g2_decap_8
XFILLER_44_951 VPWR VGND sg13g2_decap_8
XFILLER_35_439 VPWR VGND sg13g2_decap_8
XFILLER_16_653 VPWR VGND sg13g2_decap_8
XFILLER_16_686 VPWR VGND sg13g2_decap_8
XFILLER_15_185 VPWR VGND sg13g2_decap_8
XFILLER_31_623 VPWR VGND sg13g2_fill_2
XFILLER_30_122 VPWR VGND sg13g2_decap_8
XFILLER_30_133 VPWR VGND sg13g2_fill_1
XFILLER_31_656 VPWR VGND sg13g2_decap_8
X_1810_ _0336_ _0337_ _1018_ _0338_ VPWR VGND sg13g2_nand3_1
XFILLER_7_21 VPWR VGND sg13g2_decap_8
XFILLER_12_892 VPWR VGND sg13g2_decap_8
X_2790_ net92 VGND VPWR net231 falutop.div_inst.acc\[4\] clknet_5_2__leaf_clk sg13g2_dfrbpq_2
XFILLER_8_852 VPWR VGND sg13g2_decap_8
X_1741_ _0270_ _0190_ _0269_ VPWR VGND sg13g2_xnor2_1
XFILLER_7_384 VPWR VGND sg13g2_decap_8
X_1672_ _0202_ net345 net350 VPWR VGND sg13g2_nand2_1
XFILLER_7_395 VPWR VGND sg13g2_decap_8
XFILLER_7_98 VPWR VGND sg13g2_decap_8
X_2224_ VGND VPWR net383 _0693_ _0144_ _0694_ sg13g2_a21oi_1
XFILLER_39_745 VPWR VGND sg13g2_fill_2
XFILLER_38_211 VPWR VGND sg13g2_decap_8
XFILLER_38_244 VPWR VGND sg13g2_decap_8
XFILLER_27_918 VPWR VGND sg13g2_decap_8
X_2155_ VGND VPWR net291 _0645_ _0124_ _0644_ sg13g2_a21oi_1
XFILLER_38_288 VPWR VGND sg13g2_fill_2
XFILLER_19_480 VPWR VGND sg13g2_decap_8
X_2086_ _0605_ _0604_ falutop.data_in\[5\] VPWR VGND sg13g2_nand2b_1
XFILLER_22_601 VPWR VGND sg13g2_decap_8
XFILLER_35_962 VPWR VGND sg13g2_decap_8
XFILLER_22_667 VPWR VGND sg13g2_decap_8
X_1939_ _0464_ _0462_ _0463_ VPWR VGND sg13g2_nand2_1
XFILLER_27_1016 VPWR VGND sg13g2_decap_8
XFILLER_27_1027 VPWR VGND sg13g2_fill_2
XFILLER_45_704 VPWR VGND sg13g2_fill_1
XFILLER_45_726 VPWR VGND sg13g2_decap_8
XFILLER_44_214 VPWR VGND sg13g2_decap_8
XFILLER_26_951 VPWR VGND sg13g2_decap_8
XFILLER_32_409 VPWR VGND sg13g2_decap_8
XFILLER_41_921 VPWR VGND sg13g2_decap_8
XFILLER_13_634 VPWR VGND sg13g2_fill_2
XFILLER_16_63 VPWR VGND sg13g2_fill_1
XFILLER_40_442 VPWR VGND sg13g2_decap_8
XFILLER_34_1009 VPWR VGND sg13g2_decap_8
XFILLER_41_998 VPWR VGND sg13g2_decap_8
XFILLER_9_649 VPWR VGND sg13g2_decap_8
X_2789__94 VPWR VGND net94 sg13g2_tiehi
XFILLER_8_137 VPWR VGND sg13g2_decap_8
XFILLER_12_188 VPWR VGND sg13g2_fill_2
XFILLER_32_62 VPWR VGND sg13g2_decap_8
XFILLER_5_833 VPWR VGND sg13g2_decap_8
XFILLER_4_332 VPWR VGND sg13g2_fill_2
XFILLER_4_376 VPWR VGND sg13g2_decap_8
XFILLER_0_560 VPWR VGND sg13g2_decap_8
XFILLER_36_726 VPWR VGND sg13g2_decap_8
XFILLER_17_973 VPWR VGND sg13g2_decap_8
X_2911_ net123 VGND VPWR _0132_ falutop.i2c_inst.data_in\[4\] clknet_5_10__leaf_clk
+ sg13g2_dfrbpq_1
XFILLER_43_280 VPWR VGND sg13g2_fill_2
XFILLER_32_965 VPWR VGND sg13g2_decap_8
X_2842_ net170 VGND VPWR _0063_ falutop.div_inst.val\[0\] clknet_5_7__leaf_clk sg13g2_dfrbpq_2
XFILLER_31_475 VPWR VGND sg13g2_fill_2
X_2773_ net357 net273 _1159_ VPWR VGND sg13g2_nor2_1
X_1724_ _0941_ _1013_ _0253_ VPWR VGND sg13g2_nor2_1
Xhold104 _0030_ VPWR VGND net405 sg13g2_dlygate4sd3_1
Xhold126 falutop.div_inst.b1\[3\] VPWR VGND net427 sg13g2_dlygate4sd3_1
Xhold115 falutop.i2c_inst.data_in\[8\] VPWR VGND net416 sg13g2_dlygate4sd3_1
Xhold159 falutop.div_inst.b1\[7\] VPWR VGND net460 sg13g2_dlygate4sd3_1
X_1655_ VPWR _0185_ _0184_ VGND sg13g2_inv_1
Xhold148 _0041_ VPWR VGND net449 sg13g2_dlygate4sd3_1
Xhold137 falutop.i2c_inst.counter\[1\] VPWR VGND net438 sg13g2_dlygate4sd3_1
X_1586_ _1286_ net351 net345 net354 net339 VPWR VGND sg13g2_a22oi_1
XFILLER_39_520 VPWR VGND sg13g2_decap_8
X_2207_ net394 VPWR _0683_ VGND net240 _0682_ sg13g2_o21ai_1
XFILLER_27_715 VPWR VGND sg13g2_decap_8
XFILLER_27_726 VPWR VGND sg13g2_decap_8
X_2138_ _0632_ VPWR _0119_ VGND net289 _0633_ sg13g2_o21ai_1
XFILLER_26_236 VPWR VGND sg13g2_decap_8
XFILLER_42_707 VPWR VGND sg13g2_fill_2
X_2069_ _0590_ _0572_ _0589_ net282 _0939_ VPWR VGND sg13g2_a22oi_1
XFILLER_41_217 VPWR VGND sg13g2_decap_8
XFILLER_23_932 VPWR VGND sg13g2_decap_8
XFILLER_22_442 VPWR VGND sg13g2_decap_8
XFILLER_34_291 VPWR VGND sg13g2_decap_8
XFILLER_22_475 VPWR VGND sg13g2_fill_1
XFILLER_6_608 VPWR VGND sg13g2_decap_8
XFILLER_10_648 VPWR VGND sg13g2_decap_8
XFILLER_22_497 VPWR VGND sg13g2_decap_8
Xclkbuf_5_13__f_clk clknet_4_6_0_clk clknet_5_13__leaf_clk VPWR VGND sg13g2_buf_8
XFILLER_2_858 VPWR VGND sg13g2_decap_8
XFILLER_1_357 VPWR VGND sg13g2_decap_8
XFILLER_49_317 VPWR VGND sg13g2_decap_8
XFILLER_45_512 VPWR VGND sg13g2_fill_2
XFILLER_40_1024 VPWR VGND sg13g2_decap_4
XFILLER_18_726 VPWR VGND sg13g2_decap_4
XFILLER_45_578 VPWR VGND sg13g2_decap_8
XFILLER_33_718 VPWR VGND sg13g2_decap_8
XFILLER_26_781 VPWR VGND sg13g2_fill_2
XFILLER_32_217 VPWR VGND sg13g2_decap_8
XFILLER_14_976 VPWR VGND sg13g2_decap_8
XFILLER_25_280 VPWR VGND sg13g2_decap_4
XFILLER_41_795 VPWR VGND sg13g2_decap_8
XFILLER_13_497 VPWR VGND sg13g2_decap_8
Xheichips25_template_7 VPWR VGND uio_oe[2] sg13g2_tielo
XFILLER_5_630 VPWR VGND sg13g2_decap_8
XFILLER_4_151 VPWR VGND sg13g2_decap_8
XFILLER_4_11 VPWR VGND sg13g2_decap_8
XFILLER_4_88 VPWR VGND sg13g2_decap_8
XFILLER_49_895 VPWR VGND sg13g2_decap_8
XFILLER_48_394 VPWR VGND sg13g2_fill_2
XFILLER_17_781 VPWR VGND sg13g2_fill_2
XFILLER_23_228 VPWR VGND sg13g2_decap_4
XFILLER_17_1015 VPWR VGND sg13g2_decap_8
XFILLER_20_935 VPWR VGND sg13g2_decap_8
X_2825_ net43 VGND VPWR _0046_ falutop.div_inst.done clknet_5_19__leaf_clk sg13g2_dfrbpq_2
X_2756_ _1006_ _1142_ _0967_ _1143_ VPWR VGND sg13g2_nand3_1
X_2687_ net323 net343 net366 _1075_ VPWR VGND sg13g2_a21o_1
X_1707_ net391 VPWR _0237_ VGND net455 net293 sg13g2_o21ai_1
X_1638_ VGND VPWR net226 _0167_ _0169_ net303 sg13g2_a21oi_1
XFILLER_48_28 VPWR VGND sg13g2_decap_8
X_1569_ net307 VPWR _1270_ VGND falutop.div_inst.val\[3\] _1154_ sg13g2_o21ai_1
XFILLER_46_309 VPWR VGND sg13g2_fill_1
XFILLER_39_350 VPWR VGND sg13g2_decap_8
XFILLER_15_729 VPWR VGND sg13g2_fill_2
XFILLER_23_751 VPWR VGND sg13g2_decap_8
XFILLER_10_401 VPWR VGND sg13g2_decap_8
XFILLER_11_902 VPWR VGND sg13g2_decap_8
XFILLER_7_906 VPWR VGND sg13g2_decap_8
XFILLER_10_467 VPWR VGND sg13g2_decap_8
XFILLER_11_979 VPWR VGND sg13g2_decap_8
XFILLER_13_75 VPWR VGND sg13g2_fill_1
XFILLER_2_655 VPWR VGND sg13g2_decap_8
XFILLER_49_114 VPWR VGND sg13g2_decap_8
XFILLER_1_154 VPWR VGND sg13g2_decap_8
XFILLER_49_169 VPWR VGND sg13g2_decap_8
XFILLER_46_876 VPWR VGND sg13g2_decap_8
XFILLER_45_375 VPWR VGND sg13g2_decap_4
XFILLER_41_581 VPWR VGND sg13g2_decap_8
XFILLER_13_272 VPWR VGND sg13g2_decap_8
XFILLER_9_254 VPWR VGND sg13g2_decap_8
X_2610_ _0999_ net328 net309 VPWR VGND sg13g2_nand2_1
XFILLER_6_972 VPWR VGND sg13g2_decap_8
X_2541_ net339 net364 _0930_ VPWR VGND sg13g2_and2_1
XFILLER_47_1008 VPWR VGND sg13g2_decap_8
X_2472_ _0049_ _0722_ net285 net392 _0713_ VPWR VGND sg13g2_a22oi_1
XFILLER_28_309 VPWR VGND sg13g2_decap_8
XFILLER_49_692 VPWR VGND sg13g2_decap_8
XFILLER_37_843 VPWR VGND sg13g2_decap_4
XFILLER_36_320 VPWR VGND sg13g2_decap_4
XFILLER_36_353 VPWR VGND sg13g2_decap_8
XFILLER_24_515 VPWR VGND sg13g2_fill_1
XFILLER_24_559 VPWR VGND sg13g2_decap_8
X_2844__166 VPWR VGND net166 sg13g2_tiehi
XFILLER_20_743 VPWR VGND sg13g2_decap_8
Xclkload7 VPWR clkload7/Y clknet_5_21__leaf_clk VGND sg13g2_inv_1
XFILLER_30_1001 VPWR VGND sg13g2_decap_8
X_2808_ net62 VGND VPWR net247 falutop.data_in\[1\] clknet_5_14__leaf_clk sg13g2_dfrbpq_2
X_2739_ _1125_ VPWR _1126_ VGND net327 net274 sg13g2_o21ai_1
XFILLER_8_1013 VPWR VGND sg13g2_decap_8
XFILLER_46_106 VPWR VGND sg13g2_fill_1
Xfanout288 _0889_ net288 VPWR VGND sg13g2_buf_8
Xfanout277 _0738_ net277 VPWR VGND sg13g2_buf_8
Xfanout299 net300 net299 VPWR VGND sg13g2_buf_8
XFILLER_19_309 VPWR VGND sg13g2_fill_2
XFILLER_46_117 VPWR VGND sg13g2_decap_8
XFILLER_27_320 VPWR VGND sg13g2_fill_1
XFILLER_28_832 VPWR VGND sg13g2_decap_4
XFILLER_39_180 VPWR VGND sg13g2_fill_1
XFILLER_28_876 VPWR VGND sg13g2_decap_8
XFILLER_42_312 VPWR VGND sg13g2_fill_1
XFILLER_43_857 VPWR VGND sg13g2_decap_8
XFILLER_42_334 VPWR VGND sg13g2_decap_8
XFILLER_42_356 VPWR VGND sg13g2_decap_8
XFILLER_24_52 VPWR VGND sg13g2_fill_1
XFILLER_24_85 VPWR VGND sg13g2_decap_4
XFILLER_7_703 VPWR VGND sg13g2_decap_8
XFILLER_11_776 VPWR VGND sg13g2_decap_8
XFILLER_10_264 VPWR VGND sg13g2_decap_8
XFILLER_6_213 VPWR VGND sg13g2_fill_2
XFILLER_6_279 VPWR VGND sg13g2_fill_2
XFILLER_3_953 VPWR VGND sg13g2_decap_8
XFILLER_2_452 VPWR VGND sg13g2_decap_8
XFILLER_37_128 VPWR VGND sg13g2_decap_4
XFILLER_1_56 VPWR VGND sg13g2_decap_8
XFILLER_19_865 VPWR VGND sg13g2_decap_8
XFILLER_46_673 VPWR VGND sg13g2_decap_8
XFILLER_45_161 VPWR VGND sg13g2_decap_8
XFILLER_34_835 VPWR VGND sg13g2_decap_8
X_1972_ _0496_ _0491_ _0495_ VPWR VGND sg13g2_nand2_1
XFILLER_14_570 VPWR VGND sg13g2_fill_1
XFILLER_14_1018 VPWR VGND sg13g2_decap_8
XFILLER_46_0 VPWR VGND sg13g2_decap_8
X_2524_ net385 VPWR _0914_ VGND net489 net300 sg13g2_o21ai_1
X_2455_ _0879_ falutop.i2c_inst.result\[13\] _0846_ VPWR VGND sg13g2_nand2_1
X_2386_ net434 net442 _0833_ VPWR VGND sg13g2_nor2_1
Xhold19 _0006_ VPWR VGND net193 sg13g2_dlygate4sd3_1
XFILLER_29_618 VPWR VGND sg13g2_decap_8
XFILLER_28_128 VPWR VGND sg13g2_decap_8
XFILLER_37_673 VPWR VGND sg13g2_decap_8
XFILLER_25_857 VPWR VGND sg13g2_decap_8
XFILLER_40_805 VPWR VGND sg13g2_decap_8
XFILLER_40_849 VPWR VGND sg13g2_decap_8
XFILLER_20_540 VPWR VGND sg13g2_fill_1
XFILLER_20_573 VPWR VGND sg13g2_decap_8
XFILLER_10_32 VPWR VGND sg13g2_decap_8
XFILLER_3_249 VPWR VGND sg13g2_decap_8
XFILLER_10_87 VPWR VGND sg13g2_decap_8
XFILLER_0_945 VPWR VGND sg13g2_decap_8
XFILLER_47_404 VPWR VGND sg13g2_decap_8
XFILLER_19_30 VPWR VGND sg13g2_decap_8
XFILLER_48_938 VPWR VGND sg13g2_decap_8
XFILLER_19_117 VPWR VGND sg13g2_decap_8
XFILLER_19_128 VPWR VGND sg13g2_decap_8
XFILLER_19_96 VPWR VGND sg13g2_decap_4
XFILLER_19_139 VPWR VGND sg13g2_fill_2
XFILLER_28_651 VPWR VGND sg13g2_decap_8
XFILLER_16_868 VPWR VGND sg13g2_decap_8
XFILLER_27_172 VPWR VGND sg13g2_fill_2
XFILLER_15_367 VPWR VGND sg13g2_decap_8
XFILLER_31_827 VPWR VGND sg13g2_fill_2
XFILLER_35_62 VPWR VGND sg13g2_decap_8
XFILLER_42_197 VPWR VGND sg13g2_decap_8
XFILLER_7_500 VPWR VGND sg13g2_decap_8
XFILLER_11_562 VPWR VGND sg13g2_decap_8
XFILLER_7_577 VPWR VGND sg13g2_decap_8
XFILLER_3_750 VPWR VGND sg13g2_decap_8
X_2240_ VPWR _0708_ net201 VGND sg13g2_inv_1
XFILLER_39_905 VPWR VGND sg13g2_decap_8
XFILLER_38_404 VPWR VGND sg13g2_fill_2
X_2171_ _0657_ _0824_ _0846_ VPWR VGND sg13g2_nand2_2
XFILLER_18_4 VPWR VGND sg13g2_fill_2
XFILLER_46_470 VPWR VGND sg13g2_decap_4
XFILLER_18_172 VPWR VGND sg13g2_decap_8
XFILLER_18_183 VPWR VGND sg13g2_fill_1
XFILLER_33_120 VPWR VGND sg13g2_decap_8
XFILLER_21_326 VPWR VGND sg13g2_decap_4
X_1955_ _0479_ _0478_ _0462_ _0477_ _0381_ VPWR VGND sg13g2_a22oi_1
X_1886_ _0412_ _0401_ _0411_ VPWR VGND sg13g2_xnor2_1
X_2507_ VGND VPWR _0702_ net301 _0069_ _0905_ sg13g2_a21oi_1
X_2438_ net421 falutop.data_in\[12\] net313 _0040_ VPWR VGND sg13g2_mux2_1
X_2369_ VGND VPWR _0711_ net313 _0016_ _0820_ sg13g2_a21oi_1
XFILLER_29_404 VPWR VGND sg13g2_fill_1
XFILLER_29_426 VPWR VGND sg13g2_decap_4
XFILLER_37_492 VPWR VGND sg13g2_decap_8
XFILLER_13_838 VPWR VGND sg13g2_decap_8
XFILLER_40_646 VPWR VGND sg13g2_decap_8
XFILLER_12_359 VPWR VGND sg13g2_decap_8
XFILLER_21_860 VPWR VGND sg13g2_decap_8
XFILLER_21_871 VPWR VGND sg13g2_fill_2
XFILLER_4_558 VPWR VGND sg13g2_decap_8
XFILLER_43_1011 VPWR VGND sg13g2_decap_8
XFILLER_0_742 VPWR VGND sg13g2_decap_8
XFILLER_48_735 VPWR VGND sg13g2_decap_8
XFILLER_29_960 VPWR VGND sg13g2_decap_8
XFILLER_35_418 VPWR VGND sg13g2_decap_8
XFILLER_44_930 VPWR VGND sg13g2_decap_8
XFILLER_16_632 VPWR VGND sg13g2_decap_8
XFILLER_43_451 VPWR VGND sg13g2_decap_8
XFILLER_15_120 VPWR VGND sg13g2_fill_2
XFILLER_43_484 VPWR VGND sg13g2_decap_4
XFILLER_15_164 VPWR VGND sg13g2_decap_8
XFILLER_8_831 VPWR VGND sg13g2_decap_8
XFILLER_12_871 VPWR VGND sg13g2_decap_8
XFILLER_30_167 VPWR VGND sg13g2_decap_8
XFILLER_30_178 VPWR VGND sg13g2_fill_1
XFILLER_11_381 VPWR VGND sg13g2_decap_4
X_1740_ _0269_ _0260_ _0267_ VPWR VGND sg13g2_xnor2_1
XFILLER_7_77 VPWR VGND sg13g2_decap_8
X_1671_ _0717_ _0725_ _0201_ VPWR VGND sg13g2_nor2_1
X_2223_ net393 VPWR _0694_ VGND net214 _0693_ sg13g2_o21ai_1
XFILLER_38_201 VPWR VGND sg13g2_fill_1
XFILLER_39_779 VPWR VGND sg13g2_decap_8
X_2154_ _0645_ falutop.data_in\[4\] _0643_ VPWR VGND sg13g2_xnor2_1
XFILLER_26_407 VPWR VGND sg13g2_decap_8
X_2085_ falutop.data_in\[4\] _0603_ _0604_ VPWR VGND sg13g2_nor2b_1
XFILLER_35_941 VPWR VGND sg13g2_decap_8
XFILLER_34_462 VPWR VGND sg13g2_decap_8
XFILLER_21_123 VPWR VGND sg13g2_fill_2
X_1938_ _0416_ _0418_ _0461_ _0463_ VPWR VGND sg13g2_or3_1
XFILLER_21_189 VPWR VGND sg13g2_decap_4
X_1869_ VGND VPWR _0395_ _0394_ _0349_ sg13g2_or2_1
XFILLER_1_539 VPWR VGND sg13g2_decap_8
XFILLER_45_716 VPWR VGND sg13g2_decap_4
XFILLER_18_919 VPWR VGND sg13g2_decap_8
XFILLER_29_267 VPWR VGND sg13g2_decap_8
XFILLER_16_20 VPWR VGND sg13g2_decap_8
XFILLER_26_930 VPWR VGND sg13g2_decap_8
XFILLER_41_900 VPWR VGND sg13g2_decap_8
XFILLER_13_613 VPWR VGND sg13g2_decap_8
XFILLER_41_977 VPWR VGND sg13g2_decap_8
XFILLER_40_421 VPWR VGND sg13g2_decap_8
XFILLER_13_668 VPWR VGND sg13g2_fill_2
XFILLER_40_487 VPWR VGND sg13g2_decap_4
XFILLER_9_628 VPWR VGND sg13g2_decap_8
XFILLER_12_167 VPWR VGND sg13g2_decap_8
XFILLER_5_812 VPWR VGND sg13g2_decap_8
XFILLER_5_889 VPWR VGND sg13g2_decap_8
XFILLER_4_366 VPWR VGND sg13g2_fill_1
XFILLER_35_237 VPWR VGND sg13g2_decap_8
XFILLER_17_952 VPWR VGND sg13g2_decap_8
X_2910_ net127 VGND VPWR _0131_ falutop.i2c_inst.data_in\[3\] clknet_5_11__leaf_clk
+ sg13g2_dfrbpq_1
XFILLER_44_793 VPWR VGND sg13g2_fill_2
XFILLER_32_944 VPWR VGND sg13g2_decap_8
X_2841_ net171 VGND VPWR _0062_ falutop.div_inst.busy clknet_5_1__leaf_clk sg13g2_dfrbpq_1
X_2772_ _1051_ _1058_ _0960_ _1158_ VPWR VGND sg13g2_nand3_1
X_1723_ _0251_ VPWR _0252_ VGND _0222_ _0249_ sg13g2_o21ai_1
Xhold116 falutop.div_inst.acc\[0\] VPWR VGND net417 sg13g2_dlygate4sd3_1
XFILLER_7_160 VPWR VGND sg13g2_decap_8
Xhold105 falutop.div_inst.quo\[0\] VPWR VGND net406 sg13g2_dlygate4sd3_1
X_1654_ _1279_ _1281_ _0184_ VPWR VGND sg13g2_and2_1
Xhold127 _0897_ VPWR VGND net428 sg13g2_dlygate4sd3_1
Xhold149 falutop.div_inst.b\[0\] VPWR VGND net450 sg13g2_dlygate4sd3_1
Xhold138 falutop.i2c_inst.result\[12\] VPWR VGND net439 sg13g2_dlygate4sd3_1
X_1585_ net345 net339 net354 net351 _1285_ VPWR VGND sg13g2_and4_1
X_2206_ _0653_ _0675_ _0682_ VPWR VGND sg13g2_nor2_1
XFILLER_39_576 VPWR VGND sg13g2_decap_8
XFILLER_2_1019 VPWR VGND sg13g2_decap_8
X_2137_ _0631_ falutop.data_in\[14\] _0633_ VPWR VGND sg13g2_xor2_1
X_2068_ VGND VPWR _0568_ _0569_ _0589_ _0588_ sg13g2_a21oi_1
XFILLER_23_911 VPWR VGND sg13g2_decap_8
XFILLER_34_270 VPWR VGND sg13g2_decap_8
XFILLER_23_988 VPWR VGND sg13g2_decap_8
XFILLER_10_638 VPWR VGND sg13g2_decap_4
XFILLER_5_108 VPWR VGND sg13g2_fill_2
XFILLER_2_837 VPWR VGND sg13g2_decap_8
XFILLER_1_336 VPWR VGND sg13g2_decap_8
X_2854__146 VPWR VGND net146 sg13g2_tiehi
XFILLER_40_1003 VPWR VGND sg13g2_decap_8
XFILLER_18_705 VPWR VGND sg13g2_decap_8
XFILLER_17_204 VPWR VGND sg13g2_fill_1
XFILLER_27_52 VPWR VGND sg13g2_decap_8
XFILLER_26_760 VPWR VGND sg13g2_decap_8
XFILLER_41_730 VPWR VGND sg13g2_decap_4
XFILLER_14_955 VPWR VGND sg13g2_decap_8
XFILLER_41_763 VPWR VGND sg13g2_decap_4
XFILLER_13_465 VPWR VGND sg13g2_decap_8
XFILLER_43_84 VPWR VGND sg13g2_decap_8
Xheichips25_template_8 VPWR VGND uio_oe[3] sg13g2_tielo
XFILLER_4_130 VPWR VGND sg13g2_decap_8
XFILLER_5_686 VPWR VGND sg13g2_decap_8
XFILLER_4_67 VPWR VGND sg13g2_decap_8
XFILLER_49_874 VPWR VGND sg13g2_decap_8
XFILLER_48_373 VPWR VGND sg13g2_decap_8
XFILLER_24_708 VPWR VGND sg13g2_decap_8
XFILLER_24_719 VPWR VGND sg13g2_fill_2
XFILLER_36_546 VPWR VGND sg13g2_decap_8
XFILLER_17_760 VPWR VGND sg13g2_decap_8
XFILLER_17_771 VPWR VGND sg13g2_fill_2
XFILLER_23_207 VPWR VGND sg13g2_decap_8
XFILLER_44_590 VPWR VGND sg13g2_decap_4
XFILLER_20_914 VPWR VGND sg13g2_decap_8
XFILLER_32_774 VPWR VGND sg13g2_decap_4
X_2824_ net45 VGND VPWR _0045_ falutop.div_inst.quo\[0\] clknet_5_1__leaf_clk sg13g2_dfrbpq_1
XFILLER_9_992 VPWR VGND sg13g2_decap_8
X_2755_ _0965_ _0966_ _0929_ _1142_ VPWR VGND sg13g2_nand3_1
X_2686_ net323 net366 net343 _1074_ VPWR VGND sg13g2_nand3_1
X_1706_ VPWR VGND _0235_ net295 _0233_ net278 _0236_ _0232_ sg13g2_a221oi_1
X_1637_ VGND VPWR _0168_ _0167_ net226 sg13g2_or2_1
X_2791__90 VPWR VGND net90 sg13g2_tiehi
X_1568_ VPWR VGND net283 _1268_ _1235_ _1232_ _1269_ _1234_ sg13g2_a221oi_1
X_1499_ _1201_ _1195_ _1200_ VPWR VGND sg13g2_nand2_1
XFILLER_15_708 VPWR VGND sg13g2_decap_8
XFILLER_27_546 VPWR VGND sg13g2_decap_8
XFILLER_14_207 VPWR VGND sg13g2_decap_8
XFILLER_23_785 VPWR VGND sg13g2_decap_8
XFILLER_11_958 VPWR VGND sg13g2_decap_8
XFILLER_2_634 VPWR VGND sg13g2_decap_8
XFILLER_1_133 VPWR VGND sg13g2_decap_8
XFILLER_49_148 VPWR VGND sg13g2_decap_8
XFILLER_38_51 VPWR VGND sg13g2_decap_4
XFILLER_18_502 VPWR VGND sg13g2_decap_8
XFILLER_18_513 VPWR VGND sg13g2_fill_2
XFILLER_46_855 VPWR VGND sg13g2_decap_8
XFILLER_45_354 VPWR VGND sg13g2_decap_8
XFILLER_18_557 VPWR VGND sg13g2_decap_8
XFILLER_33_549 VPWR VGND sg13g2_decap_8
XFILLER_14_763 VPWR VGND sg13g2_fill_1
XFILLER_10_991 VPWR VGND sg13g2_decap_8
XFILLER_6_951 VPWR VGND sg13g2_decap_8
X_2540_ _0926_ _0928_ _0929_ VPWR VGND sg13g2_nor2_2
X_2471_ VPWR _0048_ net457 VGND sg13g2_inv_1
XFILLER_5_483 VPWR VGND sg13g2_decap_8
XFILLER_49_671 VPWR VGND sg13g2_decap_8
XFILLER_37_866 VPWR VGND sg13g2_decap_4
XFILLER_24_505 VPWR VGND sg13g2_decap_4
XFILLER_24_527 VPWR VGND sg13g2_decap_8
Xclkload8 VPWR clkload8/Y clknet_5_23__leaf_clk VGND sg13g2_inv_1
X_2807_ net63 VGND VPWR _0028_ falutop.data_in\[0\] clknet_5_12__leaf_clk sg13g2_dfrbpq_2
X_2738_ VGND VPWR _0719_ _0989_ _1125_ _0985_ sg13g2_a21oi_1
X_2669_ VGND VPWR _1057_ _1055_ _0956_ sg13g2_or2_1
Xfanout289 _0864_ net289 VPWR VGND sg13g2_buf_8
Xfanout278 _1103_ net278 VPWR VGND sg13g2_buf_8
XFILLER_39_192 VPWR VGND sg13g2_decap_8
XFILLER_27_332 VPWR VGND sg13g2_decap_8
XFILLER_28_855 VPWR VGND sg13g2_fill_2
XFILLER_43_836 VPWR VGND sg13g2_decap_8
XFILLER_15_516 VPWR VGND sg13g2_decap_8
XFILLER_23_582 VPWR VGND sg13g2_decap_8
XFILLER_11_755 VPWR VGND sg13g2_decap_8
XFILLER_7_759 VPWR VGND sg13g2_decap_8
XFILLER_40_52 VPWR VGND sg13g2_decap_8
XFILLER_6_247 VPWR VGND sg13g2_fill_1
XFILLER_3_932 VPWR VGND sg13g2_decap_8
XFILLER_2_431 VPWR VGND sg13g2_decap_8
XFILLER_38_619 VPWR VGND sg13g2_decap_4
XFILLER_37_107 VPWR VGND sg13g2_decap_8
XFILLER_1_35 VPWR VGND sg13g2_decap_8
XFILLER_19_811 VPWR VGND sg13g2_decap_4
XFILLER_46_641 VPWR VGND sg13g2_fill_2
XFILLER_46_630 VPWR VGND sg13g2_decap_8
XFILLER_18_376 VPWR VGND sg13g2_decap_8
XFILLER_33_302 VPWR VGND sg13g2_decap_8
XFILLER_45_195 VPWR VGND sg13g2_fill_2
XFILLER_18_398 VPWR VGND sg13g2_decap_8
XFILLER_34_869 VPWR VGND sg13g2_decap_8
XFILLER_21_508 VPWR VGND sg13g2_fill_2
XFILLER_42_891 VPWR VGND sg13g2_decap_8
X_1971_ _0495_ _0942_ _0493_ VPWR VGND sg13g2_xnor2_1
X_2523_ VGND VPWR _0813_ net300 _0077_ _0913_ sg13g2_a21oi_1
X_2454_ _0876_ _0877_ _0875_ _0878_ VPWR VGND sg13g2_nand3_1
X_2385_ VPWR _0832_ _0831_ VGND sg13g2_inv_1
XFILLER_39_0 VPWR VGND sg13g2_decap_8
XFILLER_29_608 VPWR VGND sg13g2_fill_2
Xinput1 ui_in[0] net1 VPWR VGND sg13g2_buf_2
XFILLER_28_107 VPWR VGND sg13g2_decap_8
XFILLER_37_652 VPWR VGND sg13g2_decap_8
XFILLER_24_302 VPWR VGND sg13g2_decap_4
XFILLER_25_814 VPWR VGND sg13g2_decap_4
XFILLER_25_836 VPWR VGND sg13g2_decap_8
XFILLER_24_368 VPWR VGND sg13g2_decap_4
XFILLER_20_552 VPWR VGND sg13g2_decap_8
XFILLER_10_11 VPWR VGND sg13g2_decap_8
XFILLER_3_228 VPWR VGND sg13g2_decap_8
XFILLER_0_924 VPWR VGND sg13g2_decap_8
XFILLER_48_917 VPWR VGND sg13g2_decap_8
XFILLER_47_438 VPWR VGND sg13g2_decap_8
XFILLER_27_151 VPWR VGND sg13g2_decap_8
XFILLER_15_313 VPWR VGND sg13g2_decap_4
XFILLER_16_847 VPWR VGND sg13g2_decap_8
XFILLER_28_696 VPWR VGND sg13g2_decap_8
XFILLER_37_1019 VPWR VGND sg13g2_decap_8
XFILLER_43_699 VPWR VGND sg13g2_decap_8
XFILLER_24_891 VPWR VGND sg13g2_decap_4
XFILLER_35_96 VPWR VGND sg13g2_decap_4
XFILLER_7_556 VPWR VGND sg13g2_decap_8
X_2170_ VGND VPWR _0700_ _0841_ _0128_ _0656_ sg13g2_a21oi_1
XFILLER_38_416 VPWR VGND sg13g2_decap_8
XFILLER_20_1012 VPWR VGND sg13g2_decap_8
XFILLER_47_994 VPWR VGND sg13g2_decap_8
XFILLER_19_685 VPWR VGND sg13g2_decap_8
XFILLER_34_600 VPWR VGND sg13g2_decap_8
XFILLER_46_493 VPWR VGND sg13g2_decap_8
XFILLER_34_622 VPWR VGND sg13g2_decap_4
XFILLER_22_806 VPWR VGND sg13g2_decap_8
XFILLER_15_880 VPWR VGND sg13g2_decap_8
XFILLER_21_305 VPWR VGND sg13g2_decap_8
XFILLER_34_688 VPWR VGND sg13g2_decap_8
X_1954_ _0478_ _0463_ _0420_ VPWR VGND sg13g2_nand2b_1
X_1885_ _0411_ _0402_ _0409_ VPWR VGND sg13g2_xnor2_1
X_2506_ net389 VPWR _0905_ VGND net194 net301 sg13g2_o21ai_1
X_2437_ net240 falutop.data_in\[11\] net313 _0039_ VPWR VGND sg13g2_mux2_1
X_2368_ net214 net313 _0820_ VPWR VGND sg13g2_nor2_1
X_2299_ VGND VPWR net276 _0759_ _0006_ _0760_ sg13g2_a21oi_1
XFILLER_38_994 VPWR VGND sg13g2_decap_8
XFILLER_13_817 VPWR VGND sg13g2_decap_8
XFILLER_12_316 VPWR VGND sg13g2_decap_8
XFILLER_25_688 VPWR VGND sg13g2_decap_4
XFILLER_24_198 VPWR VGND sg13g2_decap_8
XFILLER_4_537 VPWR VGND sg13g2_decap_8
XFILLER_0_721 VPWR VGND sg13g2_decap_8
XFILLER_0_798 VPWR VGND sg13g2_decap_8
X_2886__67 VPWR VGND net67 sg13g2_tiehi
XFILLER_46_51 VPWR VGND sg13g2_decap_8
XFILLER_16_600 VPWR VGND sg13g2_decap_8
XFILLER_46_73 VPWR VGND sg13g2_decap_4
XFILLER_46_62 VPWR VGND sg13g2_fill_1
XFILLER_44_986 VPWR VGND sg13g2_decap_8
Xclkbuf_5_0__f_clk clknet_4_0_0_clk clknet_5_0__leaf_clk VPWR VGND sg13g2_buf_8
X_2864__126 VPWR VGND net126 sg13g2_tiehi
XFILLER_15_198 VPWR VGND sg13g2_decap_8
XFILLER_8_810 VPWR VGND sg13g2_decap_8
XFILLER_12_850 VPWR VGND sg13g2_decap_8
X_2905__145 VPWR VGND net145 sg13g2_tiehi
XFILLER_11_360 VPWR VGND sg13g2_decap_8
XFILLER_8_887 VPWR VGND sg13g2_decap_8
XFILLER_7_56 VPWR VGND sg13g2_decap_8
X_1670_ _0199_ _0196_ _0200_ VPWR VGND sg13g2_xor2_1
X_2222_ _0840_ _0652_ _0693_ VPWR VGND sg13g2_nor2_1
XFILLER_39_758 VPWR VGND sg13g2_decap_8
XFILLER_39_747 VPWR VGND sg13g2_fill_1
X_2877__89 VPWR VGND net89 sg13g2_tiehi
X_2153_ net414 net291 _0644_ VPWR VGND sg13g2_nor2_1
XFILLER_26_419 VPWR VGND sg13g2_decap_8
XFILLER_47_791 VPWR VGND sg13g2_decap_8
XFILLER_35_920 VPWR VGND sg13g2_decap_8
X_2084_ falutop.data_in\[3\] _0602_ _0603_ VPWR VGND sg13g2_nor2b_1
XFILLER_35_997 VPWR VGND sg13g2_decap_8
XFILLER_10_809 VPWR VGND sg13g2_decap_8
XFILLER_22_636 VPWR VGND sg13g2_decap_8
XFILLER_21_168 VPWR VGND sg13g2_decap_8
X_1937_ _0461_ VPWR _0462_ VGND _0416_ _0418_ sg13g2_o21ai_1
X_1868_ _0394_ _0262_ _0358_ _0935_ _0915_ VPWR VGND sg13g2_a22oi_1
X_1799_ _0327_ _0318_ _0326_ VPWR VGND sg13g2_xnor2_1
XFILLER_1_518 VPWR VGND sg13g2_decap_8
XFILLER_29_246 VPWR VGND sg13g2_decap_8
XFILLER_40_400 VPWR VGND sg13g2_decap_8
X_2783__102 VPWR VGND net102 sg13g2_tiehi
XFILLER_16_87 VPWR VGND sg13g2_decap_8
XFILLER_26_986 VPWR VGND sg13g2_decap_8
XFILLER_41_956 VPWR VGND sg13g2_decap_8
XFILLER_9_607 VPWR VGND sg13g2_decap_8
XFILLER_13_647 VPWR VGND sg13g2_decap_8
XFILLER_8_117 VPWR VGND sg13g2_fill_2
XFILLER_20_190 VPWR VGND sg13g2_decap_8
XFILLER_4_334 VPWR VGND sg13g2_fill_1
XFILLER_5_868 VPWR VGND sg13g2_decap_8
XFILLER_48_500 VPWR VGND sg13g2_fill_1
XFILLER_48_544 VPWR VGND sg13g2_decap_8
XFILLER_0_595 VPWR VGND sg13g2_decap_8
XFILLER_36_706 VPWR VGND sg13g2_decap_4
XFILLER_17_931 VPWR VGND sg13g2_decap_8
XFILLER_29_780 VPWR VGND sg13g2_decap_8
XFILLER_35_216 VPWR VGND sg13g2_fill_1
XFILLER_16_452 VPWR VGND sg13g2_decap_8
XFILLER_32_923 VPWR VGND sg13g2_decap_8
XFILLER_43_282 VPWR VGND sg13g2_fill_1
X_2840_ net172 VGND VPWR net461 falutop.div_inst.b1\[7\] clknet_5_0__leaf_clk sg13g2_dfrbpq_2
XFILLER_31_477 VPWR VGND sg13g2_fill_1
XFILLER_12_691 VPWR VGND sg13g2_decap_8
X_2771_ _1156_ _1157_ _0081_ VPWR VGND sg13g2_nor2_1
X_1722_ _0250_ _1006_ _0251_ VPWR VGND sg13g2_nor2b_1
Xhold106 _0064_ VPWR VGND net407 sg13g2_dlygate4sd3_1
XFILLER_8_684 VPWR VGND sg13g2_decap_8
Xhold117 _0007_ VPWR VGND net418 sg13g2_dlygate4sd3_1
X_1653_ _1296_ VPWR _0183_ VGND _1241_ _1297_ sg13g2_o21ai_1
Xhold128 falutop.div_inst.busy VPWR VGND net429 sg13g2_dlygate4sd3_1
Xhold139 _0091_ VPWR VGND net440 sg13g2_dlygate4sd3_1
X_1584_ net340 net351 _1284_ VPWR VGND sg13g2_and2_1
X_2205_ VGND VPWR net384 _0680_ _0138_ _0681_ sg13g2_a21oi_1
XFILLER_39_555 VPWR VGND sg13g2_decap_8
X_2136_ _0632_ net184 net289 VPWR VGND sg13g2_nand2_1
X_2067_ _0588_ net280 _0587_ VPWR VGND sg13g2_nand2_1
XFILLER_35_783 VPWR VGND sg13g2_decap_8
XFILLER_23_967 VPWR VGND sg13g2_decap_8
XFILLER_22_466 VPWR VGND sg13g2_decap_8
XFILLER_33_1022 VPWR VGND sg13g2_decap_8
X_2786__99 VPWR VGND net99 sg13g2_tiehi
XFILLER_2_816 VPWR VGND sg13g2_decap_8
XFILLER_1_315 VPWR VGND sg13g2_decap_8
XFILLER_45_569 VPWR VGND sg13g2_fill_1
XFILLER_17_238 VPWR VGND sg13g2_decap_8
XFILLER_27_86 VPWR VGND sg13g2_decap_4
XFILLER_13_400 VPWR VGND sg13g2_decap_8
XFILLER_26_783 VPWR VGND sg13g2_fill_1
XFILLER_13_433 VPWR VGND sg13g2_decap_8
XFILLER_14_934 VPWR VGND sg13g2_decap_8
XFILLER_43_63 VPWR VGND sg13g2_decap_8
XFILLER_13_444 VPWR VGND sg13g2_fill_1
XFILLER_9_448 VPWR VGND sg13g2_decap_8
Xheichips25_template_9 VPWR VGND uio_oe[4] sg13g2_tielo
XFILLER_5_665 VPWR VGND sg13g2_decap_8
XFILLER_4_186 VPWR VGND sg13g2_decap_8
XFILLER_4_46 VPWR VGND sg13g2_decap_8
XFILLER_1_882 VPWR VGND sg13g2_decap_8
XFILLER_49_853 VPWR VGND sg13g2_decap_8
XFILLER_0_392 VPWR VGND sg13g2_decap_8
XFILLER_36_569 VPWR VGND sg13g2_decap_8
XFILLER_16_271 VPWR VGND sg13g2_fill_2
XFILLER_31_230 VPWR VGND sg13g2_decap_8
XFILLER_32_753 VPWR VGND sg13g2_decap_8
X_2823_ net47 VGND VPWR _0044_ falutop.i2c_inst.sda_o clknet_5_15__leaf_clk sg13g2_dfrbpq_1
XFILLER_31_274 VPWR VGND sg13g2_decap_8
XFILLER_9_971 VPWR VGND sg13g2_decap_8
X_2754_ _1141_ _0929_ _1140_ VPWR VGND sg13g2_xnor2_1
X_1705_ net303 _0234_ _0235_ VPWR VGND sg13g2_nor2_1
X_2685_ _1073_ net338 net328 VPWR VGND sg13g2_nand2_1
X_1636_ _0167_ _1270_ _0166_ VPWR VGND sg13g2_nand2_1
X_1567_ _1267_ VPWR _1268_ VGND _1019_ _1257_ sg13g2_o21ai_1
X_1498_ _1199_ _1196_ _1200_ VPWR VGND sg13g2_xor2_1
XFILLER_39_385 VPWR VGND sg13g2_decap_4
XFILLER_27_514 VPWR VGND sg13g2_decap_4
X_2119_ net371 VPWR _0619_ VGND falutop.data_in\[8\] falutop.data_in\[9\] sg13g2_o21ai_1
XFILLER_27_558 VPWR VGND sg13g2_decap_4
X_2780__105 VPWR VGND net105 sg13g2_tiehi
XFILLER_11_937 VPWR VGND sg13g2_decap_8
XFILLER_6_407 VPWR VGND sg13g2_decap_4
XFILLER_2_613 VPWR VGND sg13g2_decap_8
XFILLER_8_4 VPWR VGND sg13g2_decap_8
XFILLER_1_112 VPWR VGND sg13g2_decap_8
XFILLER_38_30 VPWR VGND sg13g2_decap_8
XFILLER_1_189 VPWR VGND sg13g2_decap_8
XFILLER_46_834 VPWR VGND sg13g2_decap_8
XFILLER_38_96 VPWR VGND sg13g2_decap_8
XFILLER_33_506 VPWR VGND sg13g2_decap_8
XFILLER_14_742 VPWR VGND sg13g2_decap_8
XFILLER_14_775 VPWR VGND sg13g2_decap_8
XFILLER_9_234 VPWR VGND sg13g2_decap_8
XFILLER_9_212 VPWR VGND sg13g2_decap_4
XFILLER_13_296 VPWR VGND sg13g2_decap_4
XFILLER_6_930 VPWR VGND sg13g2_decap_8
XFILLER_10_970 VPWR VGND sg13g2_decap_8
X_2470_ _0890_ falutop.alu_inst.op\[1\] net286 net393 net456 VPWR VGND sg13g2_a22oi_1
XFILLER_5_462 VPWR VGND sg13g2_decap_8
XFILLER_49_650 VPWR VGND sg13g2_decap_8
XFILLER_37_823 VPWR VGND sg13g2_fill_1
XFILLER_37_812 VPWR VGND sg13g2_decap_8
XFILLER_20_712 VPWR VGND sg13g2_decap_8
XFILLER_20_723 VPWR VGND sg13g2_fill_1
XFILLER_32_594 VPWR VGND sg13g2_decap_8
Xclkload9 VPWR clkload9/Y clknet_5_25__leaf_clk VGND sg13g2_inv_1
X_2806_ net64 VGND VPWR _0027_ falutop.div_inst.start clknet_5_16__leaf_clk sg13g2_dfrbpq_1
XFILLER_20_778 VPWR VGND sg13g2_decap_8
X_2737_ VGND VPWR _0992_ _1064_ _1124_ _0994_ sg13g2_a21oi_1
X_2668_ _1056_ _0956_ _1055_ VPWR VGND sg13g2_nand2_1
X_1619_ _1232_ _0149_ _1230_ _0150_ VPWR VGND sg13g2_nand3_1
X_2599_ _0988_ _0986_ _0987_ VPWR VGND sg13g2_nand2b_1
Xfanout279 _1103_ net279 VPWR VGND sg13g2_buf_1
XFILLER_43_815 VPWR VGND sg13g2_decap_8
XFILLER_27_388 VPWR VGND sg13g2_fill_2
XFILLER_11_734 VPWR VGND sg13g2_decap_8
XFILLER_24_43 VPWR VGND sg13g2_decap_8
XFILLER_24_65 VPWR VGND sg13g2_decap_8
XFILLER_7_738 VPWR VGND sg13g2_decap_8
XFILLER_10_299 VPWR VGND sg13g2_decap_8
XFILLER_3_911 VPWR VGND sg13g2_decap_8
XFILLER_2_410 VPWR VGND sg13g2_decap_8
XFILLER_3_988 VPWR VGND sg13g2_decap_8
XFILLER_2_487 VPWR VGND sg13g2_decap_8
XFILLER_49_95 VPWR VGND sg13g2_decap_8
XFILLER_1_14 VPWR VGND sg13g2_decap_8
XFILLER_45_130 VPWR VGND sg13g2_fill_2
XFILLER_34_848 VPWR VGND sg13g2_decap_8
X_1970_ _0494_ _0493_ _0942_ VPWR VGND sg13g2_nand2b_1
XFILLER_42_870 VPWR VGND sg13g2_decap_8
XFILLER_14_594 VPWR VGND sg13g2_fill_2
X_2522_ net385 VPWR _0913_ VGND net501 net300 sg13g2_o21ai_1
X_2874__106 VPWR VGND net106 sg13g2_tiehi
XFILLER_5_292 VPWR VGND sg13g2_fill_2
X_2453_ _0877_ _0845_ falutop.i2c_inst.result\[10\] net310 falutop.i2c_inst.result\[8\]
+ VPWR VGND sg13g2_a22oi_1
X_2384_ _0827_ VPWR _0831_ VGND _0826_ _0830_ sg13g2_o21ai_1
Xinput2 ui_in[1] net2 VPWR VGND sg13g2_buf_2
XFILLER_37_642 VPWR VGND sg13g2_fill_2
XFILLER_36_141 VPWR VGND sg13g2_decap_8
XFILLER_36_196 VPWR VGND sg13g2_decap_8
XFILLER_12_509 VPWR VGND sg13g2_decap_8
XFILLER_4_719 VPWR VGND sg13g2_decap_8
XFILLER_3_207 VPWR VGND sg13g2_decap_8
XFILLER_10_67 VPWR VGND sg13g2_fill_2
XFILLER_0_903 VPWR VGND sg13g2_decap_8
XFILLER_16_804 VPWR VGND sg13g2_decap_8
XFILLER_27_130 VPWR VGND sg13g2_fill_1
XFILLER_43_612 VPWR VGND sg13g2_decap_4
XFILLER_42_111 VPWR VGND sg13g2_fill_2
XFILLER_43_678 VPWR VGND sg13g2_decap_8
XFILLER_42_188 VPWR VGND sg13g2_fill_2
XFILLER_30_317 VPWR VGND sg13g2_decap_8
Xclkbuf_5_19__f_clk clknet_4_9_0_clk clknet_5_19__leaf_clk VPWR VGND sg13g2_buf_8
XFILLER_30_339 VPWR VGND sg13g2_decap_8
XFILLER_7_535 VPWR VGND sg13g2_decap_8
XFILLER_11_597 VPWR VGND sg13g2_decap_4
XFILLER_13_1020 VPWR VGND sg13g2_decap_8
XFILLER_3_785 VPWR VGND sg13g2_decap_8
XFILLER_2_284 VPWR VGND sg13g2_decap_8
XFILLER_38_406 VPWR VGND sg13g2_fill_1
XFILLER_18_6 VPWR VGND sg13g2_fill_1
XFILLER_19_642 VPWR VGND sg13g2_decap_8
XFILLER_47_973 VPWR VGND sg13g2_decap_8
XFILLER_46_483 VPWR VGND sg13g2_decap_4
XFILLER_34_612 VPWR VGND sg13g2_decap_4
XFILLER_33_155 VPWR VGND sg13g2_decap_4
XFILLER_33_188 VPWR VGND sg13g2_fill_2
X_1953_ _0477_ _0423_ _0462_ _0476_ VPWR VGND sg13g2_and3_1
X_1884_ _0402_ _0409_ _0410_ VPWR VGND sg13g2_nor2b_1
X_2505_ VGND VPWR _0703_ net302 _0068_ _0904_ sg13g2_a21oi_1
X_2436_ net255 falutop.data_in\[10\] net313 _0038_ VPWR VGND sg13g2_mux2_1
X_2367_ falutop.i2c_inst.state\[0\] net387 falutop.i2c_inst.state\[1\] _0819_ VPWR
+ VGND sg13g2_nand3_1
X_2298_ net192 net276 _0760_ VPWR VGND sg13g2_nor2_1
XFILLER_44_409 VPWR VGND sg13g2_decap_8
XFILLER_38_973 VPWR VGND sg13g2_decap_8
XFILLER_37_472 VPWR VGND sg13g2_decap_8
XFILLER_24_144 VPWR VGND sg13g2_decap_8
XFILLER_25_667 VPWR VGND sg13g2_decap_8
XFILLER_40_604 VPWR VGND sg13g2_decap_8
XFILLER_24_155 VPWR VGND sg13g2_fill_1
XFILLER_20_350 VPWR VGND sg13g2_fill_2
XFILLER_4_516 VPWR VGND sg13g2_decap_8
XFILLER_21_55 VPWR VGND sg13g2_fill_1
XFILLER_0_700 VPWR VGND sg13g2_decap_8
XFILLER_0_777 VPWR VGND sg13g2_decap_8
XFILLER_47_236 VPWR VGND sg13g2_decap_8
XFILLER_47_269 VPWR VGND sg13g2_decap_8
XFILLER_28_461 VPWR VGND sg13g2_fill_1
XFILLER_29_995 VPWR VGND sg13g2_decap_8
XFILLER_44_965 VPWR VGND sg13g2_decap_8
XFILLER_43_431 VPWR VGND sg13g2_decap_8
XFILLER_15_122 VPWR VGND sg13g2_fill_1
XFILLER_31_604 VPWR VGND sg13g2_decap_8
XFILLER_7_321 VPWR VGND sg13g2_decap_8
XFILLER_7_35 VPWR VGND sg13g2_decap_8
XFILLER_8_866 VPWR VGND sg13g2_decap_8
XFILLER_3_582 VPWR VGND sg13g2_decap_8
X_2221_ VGND VPWR net383 _0691_ _0143_ _0692_ sg13g2_a21oi_1
XFILLER_30_5 VPWR VGND sg13g2_decap_8
XFILLER_39_726 VPWR VGND sg13g2_decap_8
XFILLER_23_4 VPWR VGND sg13g2_decap_8
X_2152_ _0603_ net373 _0643_ VPWR VGND sg13g2_nor2b_1
X_2083_ net207 falutop.data_in\[1\] falutop.data_in\[2\] _0602_ VPWR VGND sg13g2_nor3_1
XFILLER_47_770 VPWR VGND sg13g2_decap_8
XFILLER_46_291 VPWR VGND sg13g2_decap_8
XFILLER_19_494 VPWR VGND sg13g2_decap_8
XFILLER_35_976 VPWR VGND sg13g2_decap_8
XFILLER_22_615 VPWR VGND sg13g2_decap_8
X_1936_ _0461_ _0395_ _0459_ VPWR VGND sg13g2_xnor2_1
X_1867_ VGND VPWR _0355_ _0370_ _0393_ _0369_ sg13g2_a21oi_1
X_1798_ _0326_ _0319_ _0324_ VPWR VGND sg13g2_xnor2_1
X_2419_ _0711_ falutop.i2c_inst.op\[1\] _0712_ _0713_ _0860_ VPWR VGND sg13g2_or4_1
XFILLER_29_225 VPWR VGND sg13g2_decap_8
XFILLER_44_228 VPWR VGND sg13g2_fill_2
XFILLER_25_420 VPWR VGND sg13g2_fill_1
XFILLER_26_965 VPWR VGND sg13g2_decap_8
XFILLER_41_935 VPWR VGND sg13g2_decap_8
XFILLER_25_475 VPWR VGND sg13g2_fill_1
XFILLER_12_125 VPWR VGND sg13g2_fill_2
XFILLER_40_456 VPWR VGND sg13g2_decap_4
XFILLER_32_76 VPWR VGND sg13g2_decap_8
XFILLER_5_847 VPWR VGND sg13g2_decap_8
XFILLER_10_1012 VPWR VGND sg13g2_decap_8
XFILLER_0_574 VPWR VGND sg13g2_decap_8
XFILLER_17_910 VPWR VGND sg13g2_decap_8
XFILLER_17_987 VPWR VGND sg13g2_decap_8
XFILLER_32_902 VPWR VGND sg13g2_decap_8
XFILLER_32_979 VPWR VGND sg13g2_decap_8
XFILLER_12_670 VPWR VGND sg13g2_decap_8
X_2770_ net390 VPWR _1157_ VGND net486 net293 sg13g2_o21ai_1
XFILLER_8_663 VPWR VGND sg13g2_decap_8
X_1721_ _0941_ _0976_ _0250_ VPWR VGND sg13g2_nor2_1
Xhold107 falutop.i2c_inst.state\[0\] VPWR VGND net408 sg13g2_dlygate4sd3_1
X_1652_ net281 _0180_ _0182_ VPWR VGND _0181_ sg13g2_nand3b_1
Xhold118 falutop.div_inst.a\[7\] VPWR VGND net419 sg13g2_dlygate4sd3_1
Xhold129 falutop.i2c_inst.data_in\[14\] VPWR VGND net430 sg13g2_dlygate4sd3_1
XFILLER_4_880 VPWR VGND sg13g2_decap_8
X_1583_ _1283_ net325 net367 VPWR VGND sg13g2_nand2_1
X_2204_ net391 VPWR _0681_ VGND net255 _0680_ sg13g2_o21ai_1
XFILLER_39_534 VPWR VGND sg13g2_decap_8
X_2135_ _0631_ net370 _0599_ VPWR VGND sg13g2_nand2_1
XFILLER_26_206 VPWR VGND sg13g2_fill_1
X_2066_ _0587_ _0583_ _0586_ VPWR VGND sg13g2_xnor2_1
XFILLER_35_740 VPWR VGND sg13g2_fill_1
XFILLER_35_762 VPWR VGND sg13g2_decap_8
XFILLER_22_423 VPWR VGND sg13g2_fill_1
XFILLER_23_946 VPWR VGND sg13g2_decap_8
XFILLER_22_456 VPWR VGND sg13g2_decap_4
XFILLER_33_1001 VPWR VGND sg13g2_decap_8
XFILLER_31_990 VPWR VGND sg13g2_decap_8
X_1919_ VGND VPWR net320 _1307_ _0444_ _0442_ sg13g2_a21oi_1
X_2899_ net157 VGND VPWR _0120_ falutop.div_inst.b\[0\] clknet_5_12__leaf_clk sg13g2_dfrbpq_2
XFILLER_17_217 VPWR VGND sg13g2_decap_4
XFILLER_27_21 VPWR VGND sg13g2_decap_8
XFILLER_45_548 VPWR VGND sg13g2_decap_8
XFILLER_14_913 VPWR VGND sg13g2_decap_8
XFILLER_25_294 VPWR VGND sg13g2_fill_2
XFILLER_40_253 VPWR VGND sg13g2_fill_1
XFILLER_40_231 VPWR VGND sg13g2_fill_2
XFILLER_40_275 VPWR VGND sg13g2_decap_8
XFILLER_22_990 VPWR VGND sg13g2_decap_8
XFILLER_5_644 VPWR VGND sg13g2_decap_8
XFILLER_4_165 VPWR VGND sg13g2_decap_8
XFILLER_4_25 VPWR VGND sg13g2_decap_8
XFILLER_1_861 VPWR VGND sg13g2_decap_8
XFILLER_49_832 VPWR VGND sg13g2_decap_8
XFILLER_48_320 VPWR VGND sg13g2_fill_2
XFILLER_0_371 VPWR VGND sg13g2_decap_8
XFILLER_16_250 VPWR VGND sg13g2_decap_8
XFILLER_16_283 VPWR VGND sg13g2_decap_8
XFILLER_16_294 VPWR VGND sg13g2_fill_2
X_2822_ net48 VGND VPWR net249 falutop.data_in\[15\] clknet_5_26__leaf_clk sg13g2_dfrbpq_1
XFILLER_20_949 VPWR VGND sg13g2_decap_8
XFILLER_9_950 VPWR VGND sg13g2_decap_8
X_2753_ VGND VPWR net309 _0933_ _1140_ net308 sg13g2_a21oi_1
X_1704_ VGND VPWR net307 _0168_ _0234_ net194 sg13g2_a21oi_1
X_2684_ _1066_ VPWR _1072_ VGND _0986_ _1071_ sg13g2_o21ai_1
X_1635_ _0166_ falutop.div_inst.val\[4\] net307 VPWR VGND sg13g2_nand2_1
X_1566_ VPWR VGND _1088_ _1266_ _1260_ _1006_ _1267_ _1258_ sg13g2_a221oi_1
X_1497_ _1199_ _1197_ _1198_ VPWR VGND sg13g2_nand2_1
XFILLER_39_364 VPWR VGND sg13g2_fill_1
X_2118_ _0616_ VPWR _0114_ VGND net290 _0618_ sg13g2_o21ai_1
X_2049_ _0544_ _0557_ _0570_ _0571_ VPWR VGND sg13g2_or3_1
XFILLER_42_529 VPWR VGND sg13g2_decap_8
XFILLER_11_916 VPWR VGND sg13g2_decap_8
XFILLER_23_765 VPWR VGND sg13g2_fill_2
XFILLER_10_426 VPWR VGND sg13g2_fill_1
XFILLER_10_415 VPWR VGND sg13g2_decap_8
XFILLER_10_448 VPWR VGND sg13g2_decap_8
XFILLER_13_45 VPWR VGND sg13g2_fill_2
XFILLER_13_89 VPWR VGND sg13g2_fill_2
XFILLER_2_669 VPWR VGND sg13g2_decap_8
XFILLER_49_128 VPWR VGND sg13g2_decap_8
XFILLER_1_168 VPWR VGND sg13g2_decap_8
XFILLER_46_813 VPWR VGND sg13g2_decap_8
XFILLER_18_526 VPWR VGND sg13g2_decap_8
XFILLER_26_592 VPWR VGND sg13g2_decap_8
XFILLER_9_279 VPWR VGND sg13g2_decap_8
XFILLER_6_986 VPWR VGND sg13g2_decap_8
XFILLER_37_879 VPWR VGND sg13g2_decap_8
X_2805_ net66 VGND VPWR net409 falutop.i2c_inst.counter\[4\] clknet_5_26__leaf_clk
+ sg13g2_dfrbpq_2
XFILLER_20_757 VPWR VGND sg13g2_decap_8
XFILLER_30_1015 VPWR VGND sg13g2_decap_8
X_2736_ _1122_ _1121_ _1123_ VPWR VGND sg13g2_nor2b_1
X_2667_ _1055_ _1053_ _1054_ VPWR VGND sg13g2_xnor2_1
X_1618_ _0149_ _1315_ _0147_ VPWR VGND sg13g2_xnor2_1
X_2598_ VGND VPWR net338 _0718_ _0987_ net334 sg13g2_a21oi_1
XFILLER_8_1027 VPWR VGND sg13g2_fill_2
X_1549_ _1250_ _1245_ _1248_ VPWR VGND sg13g2_xnor2_1
Xfanout269 net270 net269 VPWR VGND sg13g2_buf_8
XFILLER_28_802 VPWR VGND sg13g2_fill_1
XFILLER_28_824 VPWR VGND sg13g2_fill_1
XFILLER_27_367 VPWR VGND sg13g2_fill_2
XFILLER_11_713 VPWR VGND sg13g2_decap_8
XFILLER_23_562 VPWR VGND sg13g2_decap_8
XFILLER_24_99 VPWR VGND sg13g2_decap_8
XFILLER_7_717 VPWR VGND sg13g2_decap_8
XFILLER_40_32 VPWR VGND sg13g2_decap_8
XFILLER_40_21 VPWR VGND sg13g2_fill_2
XFILLER_10_278 VPWR VGND sg13g2_fill_1
XFILLER_6_227 VPWR VGND sg13g2_decap_8
XFILLER_3_967 VPWR VGND sg13g2_decap_8
XFILLER_2_466 VPWR VGND sg13g2_decap_8
XFILLER_49_74 VPWR VGND sg13g2_decap_8
XFILLER_18_323 VPWR VGND sg13g2_decap_8
XFILLER_19_835 VPWR VGND sg13g2_decap_8
XFILLER_19_879 VPWR VGND sg13g2_decap_8
XFILLER_45_197 VPWR VGND sg13g2_fill_1
X_2521_ VGND VPWR _0809_ net299 _0076_ _0912_ sg13g2_a21oi_1
XFILLER_6_783 VPWR VGND sg13g2_decap_8
X_2452_ falutop.i2c_inst.counter\[1\] falutop.i2c_inst.counter\[0\] falutop.i2c_inst.result\[11\]
+ _0876_ VPWR VGND sg13g2_nand3_1
X_2383_ _0830_ net379 net310 VPWR VGND sg13g2_xnor2_1
Xinput3 ui_in[3] net3 VPWR VGND sg13g2_buf_1
XFILLER_36_120 VPWR VGND sg13g2_decap_8
XFILLER_36_175 VPWR VGND sg13g2_decap_8
XFILLER_40_819 VPWR VGND sg13g2_decap_8
XFILLER_24_337 VPWR VGND sg13g2_fill_2
XFILLER_33_860 VPWR VGND sg13g2_decap_4
XFILLER_33_882 VPWR VGND sg13g2_decap_8
XFILLER_20_510 VPWR VGND sg13g2_fill_2
XFILLER_20_587 VPWR VGND sg13g2_decap_8
X_2719_ _1058_ _1105_ _1106_ VPWR VGND sg13g2_nor2_1
XFILLER_10_46 VPWR VGND sg13g2_decap_8
XFILLER_0_959 VPWR VGND sg13g2_decap_8
XFILLER_19_11 VPWR VGND sg13g2_fill_1
XFILLER_47_418 VPWR VGND sg13g2_fill_2
XFILLER_19_44 VPWR VGND sg13g2_fill_2
XFILLER_19_55 VPWR VGND sg13g2_fill_2
XFILLER_19_66 VPWR VGND sg13g2_decap_8
XFILLER_28_665 VPWR VGND sg13g2_decap_8
XFILLER_43_635 VPWR VGND sg13g2_decap_8
XFILLER_35_21 VPWR VGND sg13g2_fill_2
XFILLER_42_123 VPWR VGND sg13g2_decap_4
X_2807__63 VPWR VGND net63 sg13g2_tiehi
XFILLER_15_337 VPWR VGND sg13g2_decap_8
XFILLER_27_197 VPWR VGND sg13g2_decap_8
XFILLER_35_76 VPWR VGND sg13g2_decap_8
XFILLER_42_156 VPWR VGND sg13g2_decap_8
XFILLER_7_514 VPWR VGND sg13g2_decap_8
XFILLER_3_764 VPWR VGND sg13g2_decap_8
X_2889__44 VPWR VGND net44 sg13g2_tiehi
XFILLER_2_263 VPWR VGND sg13g2_decap_8
XFILLER_39_919 VPWR VGND sg13g2_decap_8
XFILLER_19_621 VPWR VGND sg13g2_decap_8
XFILLER_47_952 VPWR VGND sg13g2_decap_8
XFILLER_33_112 VPWR VGND sg13g2_decap_4
XFILLER_33_134 VPWR VGND sg13g2_decap_8
XFILLER_22_819 VPWR VGND sg13g2_fill_2
X_1952_ _0476_ _0421_ _0463_ VPWR VGND sg13g2_nand2_1
XFILLER_14_381 VPWR VGND sg13g2_decap_8
XFILLER_30_830 VPWR VGND sg13g2_decap_8
X_1883_ _0409_ _0403_ _0408_ VPWR VGND sg13g2_xnor2_1
XFILLER_30_852 VPWR VGND sg13g2_decap_4
XFILLER_30_896 VPWR VGND sg13g2_decap_8
XFILLER_6_580 VPWR VGND sg13g2_decap_8
XFILLER_44_0 VPWR VGND sg13g2_decap_8
X_2504_ net389 VPWR _0904_ VGND net226 net302 sg13g2_o21ai_1
X_2435_ net244 falutop.data_in\[9\] net313 _0037_ VPWR VGND sg13g2_mux2_1
X_2366_ _0818_ net176 net408 VPWR VGND sg13g2_nand2_1
XFILLER_5_1008 VPWR VGND sg13g2_decap_8
X_2297_ VGND VPWR net374 net184 _0759_ _0758_ sg13g2_a21oi_1
Xclkbuf_5_25__f_clk clknet_4_12_0_clk clknet_5_25__leaf_clk VPWR VGND sg13g2_buf_8
XFILLER_38_952 VPWR VGND sg13g2_decap_8
XFILLER_25_646 VPWR VGND sg13g2_decap_8
XFILLER_21_34 VPWR VGND sg13g2_decap_8
XFILLER_21_78 VPWR VGND sg13g2_decap_8
XFILLER_0_756 VPWR VGND sg13g2_decap_8
XFILLER_43_1025 VPWR VGND sg13g2_decap_4
XFILLER_48_749 VPWR VGND sg13g2_decap_8
XFILLER_29_974 VPWR VGND sg13g2_decap_8
XFILLER_43_410 VPWR VGND sg13g2_decap_8
XFILLER_15_101 VPWR VGND sg13g2_decap_4
XFILLER_44_944 VPWR VGND sg13g2_decap_8
XFILLER_16_646 VPWR VGND sg13g2_decap_8
XFILLER_15_178 VPWR VGND sg13g2_decap_8
XFILLER_16_679 VPWR VGND sg13g2_decap_8
XFILLER_31_616 VPWR VGND sg13g2_decap_8
XFILLER_31_649 VPWR VGND sg13g2_decap_8
XFILLER_8_845 VPWR VGND sg13g2_decap_8
XFILLER_7_300 VPWR VGND sg13g2_decap_8
XFILLER_7_14 VPWR VGND sg13g2_decap_8
XFILLER_12_885 VPWR VGND sg13g2_decap_8
XFILLER_7_377 VPWR VGND sg13g2_decap_8
X_2840__172 VPWR VGND net172 sg13g2_tiehi
XFILLER_3_561 VPWR VGND sg13g2_decap_8
X_2220_ net388 VPWR _0692_ VGND net248 _0691_ sg13g2_o21ai_1
XFILLER_39_705 VPWR VGND sg13g2_fill_1
XFILLER_39_738 VPWR VGND sg13g2_decap_8
XFILLER_38_237 VPWR VGND sg13g2_decap_8
XFILLER_16_4 VPWR VGND sg13g2_decap_4
X_2151_ VGND VPWR net291 _0642_ _0123_ _0640_ sg13g2_a21oi_1
X_2082_ VPWR _0095_ net420 VGND sg13g2_inv_1
XFILLER_19_440 VPWR VGND sg13g2_decap_8
XFILLER_46_270 VPWR VGND sg13g2_decap_8
XFILLER_34_421 VPWR VGND sg13g2_fill_2
XFILLER_35_955 VPWR VGND sg13g2_decap_8
XFILLER_34_476 VPWR VGND sg13g2_fill_1
X_1935_ _0460_ _0459_ _0395_ VPWR VGND sg13g2_nand2b_1
X_1866_ _0352_ VPWR _0392_ VGND _0307_ _0353_ sg13g2_o21ai_1
X_1797_ _0325_ _0319_ _0324_ VPWR VGND sg13g2_nand2_1
XFILLER_27_1009 VPWR VGND sg13g2_decap_8
X_2418_ _0711_ falutop.i2c_inst.op\[1\] _0712_ _0713_ _0859_ VPWR VGND sg13g2_nor4_1
X_2349_ _0804_ VPWR _0805_ VGND net230 net270 sg13g2_o21ai_1
XFILLER_38_793 VPWR VGND sg13g2_decap_8
X_2876__91 VPWR VGND net91 sg13g2_tiehi
XFILLER_37_281 VPWR VGND sg13g2_decap_8
XFILLER_25_410 VPWR VGND sg13g2_fill_1
XFILLER_25_443 VPWR VGND sg13g2_decap_4
XFILLER_26_944 VPWR VGND sg13g2_decap_8
XFILLER_41_914 VPWR VGND sg13g2_decap_8
XFILLER_40_435 VPWR VGND sg13g2_fill_2
XFILLER_13_627 VPWR VGND sg13g2_decap_8
XFILLER_32_11 VPWR VGND sg13g2_decap_8
XFILLER_32_55 VPWR VGND sg13g2_decap_8
XFILLER_20_170 VPWR VGND sg13g2_decap_8
XFILLER_5_826 VPWR VGND sg13g2_decap_8
XFILLER_4_325 VPWR VGND sg13g2_decap_8
XFILLER_32_99 VPWR VGND sg13g2_decap_8
XFILLER_0_553 VPWR VGND sg13g2_decap_8
XFILLER_36_719 VPWR VGND sg13g2_decap_8
XFILLER_44_730 VPWR VGND sg13g2_decap_4
XFILLER_17_966 VPWR VGND sg13g2_decap_8
XFILLER_28_281 VPWR VGND sg13g2_decap_8
XFILLER_44_763 VPWR VGND sg13g2_decap_4
XFILLER_43_240 VPWR VGND sg13g2_decap_8
XFILLER_31_402 VPWR VGND sg13g2_decap_8
XFILLER_43_273 VPWR VGND sg13g2_decap_8
XFILLER_16_498 VPWR VGND sg13g2_decap_8
XFILLER_32_958 VPWR VGND sg13g2_decap_8
XFILLER_31_468 VPWR VGND sg13g2_decap_8
XFILLER_8_642 VPWR VGND sg13g2_decap_8
X_1720_ _0941_ VPWR _0249_ VGND net319 _0725_ sg13g2_o21ai_1
Xhold108 _0026_ VPWR VGND net409 sg13g2_dlygate4sd3_1
XFILLER_7_174 VPWR VGND sg13g2_decap_4
X_1651_ VGND VPWR _0148_ _0151_ _0181_ _0179_ sg13g2_a21oi_1
Xhold119 _0601_ VPWR VGND net420 sg13g2_dlygate4sd3_1
X_1582_ _1282_ _1239_ _1280_ VPWR VGND sg13g2_xnor2_1
X_2203_ _0660_ _0675_ _0680_ VPWR VGND sg13g2_nor2_1
X_2134_ _0630_ VPWR _0118_ VGND net290 _0629_ sg13g2_o21ai_1
XFILLER_27_708 VPWR VGND sg13g2_decap_8
X_2065_ _0586_ _0584_ _0585_ VPWR VGND sg13g2_xnor2_1
XFILLER_26_229 VPWR VGND sg13g2_decap_8
XFILLER_23_925 VPWR VGND sg13g2_decap_8
XFILLER_35_752 VPWR VGND sg13g2_decap_4
XFILLER_22_402 VPWR VGND sg13g2_decap_8
XFILLER_34_284 VPWR VGND sg13g2_decap_8
X_1918_ _0443_ net320 _1307_ VPWR VGND sg13g2_nand2_1
X_2898_ net159 VGND VPWR net185 falutop.div_inst.a\[6\] clknet_5_4__leaf_clk sg13g2_dfrbpq_1
X_1849_ VGND VPWR _0302_ _0332_ _0376_ _0331_ sg13g2_a21oi_1
XFILLER_40_1028 VPWR VGND sg13g2_fill_1
XFILLER_40_1017 VPWR VGND sg13g2_decap_8
XFILLER_18_719 VPWR VGND sg13g2_decap_8
XFILLER_26_741 VPWR VGND sg13g2_decap_8
XFILLER_27_66 VPWR VGND sg13g2_fill_2
XFILLER_26_774 VPWR VGND sg13g2_decap_8
XFILLER_43_21 VPWR VGND sg13g2_decap_8
XFILLER_25_273 VPWR VGND sg13g2_decap_8
XFILLER_25_284 VPWR VGND sg13g2_fill_1
XFILLER_14_969 VPWR VGND sg13g2_decap_8
XFILLER_43_98 VPWR VGND sg13g2_decap_4
XFILLER_41_788 VPWR VGND sg13g2_decap_8
XFILLER_5_623 VPWR VGND sg13g2_decap_8
XFILLER_4_144 VPWR VGND sg13g2_decap_8
XFILLER_1_840 VPWR VGND sg13g2_decap_8
XFILLER_49_811 VPWR VGND sg13g2_decap_8
XFILLER_0_350 VPWR VGND sg13g2_decap_8
XFILLER_49_888 VPWR VGND sg13g2_decap_8
XFILLER_1_1022 VPWR VGND sg13g2_decap_8
XFILLER_32_700 VPWR VGND sg13g2_decap_8
XFILLER_32_711 VPWR VGND sg13g2_fill_1
XFILLER_17_1008 VPWR VGND sg13g2_decap_8
XFILLER_20_928 VPWR VGND sg13g2_decap_8
X_2821_ net49 VGND VPWR net431 falutop.data_in\[14\] clknet_5_7__leaf_clk sg13g2_dfrbpq_2
XFILLER_32_799 VPWR VGND sg13g2_decap_8
X_2752_ _1139_ _1008_ _0928_ VPWR VGND sg13g2_nand2b_1
X_1703_ net307 _0168_ net194 _0233_ VPWR VGND sg13g2_nand3_1
XFILLER_8_494 VPWR VGND sg13g2_fill_2
X_2683_ _1068_ _1070_ _0985_ _1071_ VPWR VGND sg13g2_mux2_1
X_1634_ _0164_ VPWR _0165_ VGND _1019_ _1304_ sg13g2_o21ai_1
X_1565_ _1263_ _1265_ _1062_ _1266_ VPWR VGND sg13g2_nand3_1
XFILLER_39_310 VPWR VGND sg13g2_decap_8
X_1496_ net317 net344 net358 _1198_ VPWR VGND sg13g2_a21o_1
XFILLER_39_343 VPWR VGND sg13g2_decap_8
X_2117_ _0617_ falutop.data_in\[9\] _0618_ VPWR VGND sg13g2_xor2_1
X_2048_ _0569_ _0568_ _0570_ VPWR VGND sg13g2_xor2_1
XFILLER_22_243 VPWR VGND sg13g2_fill_2
XFILLER_10_438 VPWR VGND sg13g2_decap_4
XFILLER_13_57 VPWR VGND sg13g2_fill_1
XFILLER_2_648 VPWR VGND sg13g2_decap_8
XFILLER_1_147 VPWR VGND sg13g2_decap_8
XFILLER_49_107 VPWR VGND sg13g2_decap_8
X_2829__39 VPWR VGND net39 sg13g2_tiehi
XFILLER_46_869 VPWR VGND sg13g2_decap_8
XFILLER_45_379 VPWR VGND sg13g2_fill_1
XFILLER_45_368 VPWR VGND sg13g2_decap_8
XFILLER_14_711 VPWR VGND sg13g2_decap_8
XFILLER_9_247 VPWR VGND sg13g2_decap_8
XFILLER_6_965 VPWR VGND sg13g2_decap_8
XFILLER_48_7 VPWR VGND sg13g2_decap_8
XFILLER_5_497 VPWR VGND sg13g2_decap_8
XFILLER_23_1023 VPWR VGND sg13g2_decap_4
Xclkbuf_5_6__f_clk clknet_4_3_0_clk clknet_5_6__leaf_clk VPWR VGND sg13g2_buf_8
XFILLER_49_685 VPWR VGND sg13g2_decap_8
XFILLER_37_847 VPWR VGND sg13g2_fill_1
XFILLER_37_836 VPWR VGND sg13g2_decap_8
XFILLER_36_324 VPWR VGND sg13g2_fill_1
XFILLER_36_379 VPWR VGND sg13g2_fill_2
XFILLER_32_552 VPWR VGND sg13g2_fill_2
X_2804_ net68 VGND VPWR _0025_ falutop.i2c_inst.counter\[3\] clknet_5_27__leaf_clk
+ sg13g2_dfrbpq_2
XFILLER_20_736 VPWR VGND sg13g2_decap_8
X_2735_ net281 VPWR _1122_ VGND _1078_ _1120_ sg13g2_o21ai_1
X_2666_ VGND VPWR _0923_ _0954_ _1054_ _0953_ sg13g2_a21oi_1
X_1617_ _0148_ _1315_ _0147_ VPWR VGND sg13g2_nand2_1
XFILLER_8_1006 VPWR VGND sg13g2_decap_8
XFILLER_5_91 VPWR VGND sg13g2_decap_8
X_2597_ _0982_ _0984_ _0986_ VPWR VGND sg13g2_nor2b_2
X_1548_ _1249_ _1248_ _1245_ VPWR VGND sg13g2_nand2b_1
X_1479_ _1008_ VPWR _1181_ VGND net334 net357 sg13g2_o21ai_1
XFILLER_27_302 VPWR VGND sg13g2_fill_1
XFILLER_27_346 VPWR VGND sg13g2_decap_4
XFILLER_28_869 VPWR VGND sg13g2_decap_8
XFILLER_42_305 VPWR VGND sg13g2_decap_8
X_2834__31 VPWR VGND net31 sg13g2_tiehi
XFILLER_42_349 VPWR VGND sg13g2_decap_8
XFILLER_23_541 VPWR VGND sg13g2_decap_8
XFILLER_23_596 VPWR VGND sg13g2_decap_8
XFILLER_24_89 VPWR VGND sg13g2_fill_1
XFILLER_10_257 VPWR VGND sg13g2_decap_8
XFILLER_6_206 VPWR VGND sg13g2_decap_8
XFILLER_11_769 VPWR VGND sg13g2_decap_8
XFILLER_40_77 VPWR VGND sg13g2_decap_8
XFILLER_3_946 VPWR VGND sg13g2_decap_8
XFILLER_46_1023 VPWR VGND sg13g2_decap_4
XFILLER_2_445 VPWR VGND sg13g2_decap_8
XFILLER_49_42 VPWR VGND sg13g2_decap_8
XFILLER_1_49 VPWR VGND sg13g2_decap_8
XFILLER_19_858 VPWR VGND sg13g2_decap_8
XFILLER_46_666 VPWR VGND sg13g2_decap_8
XFILLER_45_132 VPWR VGND sg13g2_fill_1
XFILLER_45_176 VPWR VGND sg13g2_fill_2
XFILLER_33_316 VPWR VGND sg13g2_decap_4
XFILLER_34_828 VPWR VGND sg13g2_decap_8
XFILLER_14_563 VPWR VGND sg13g2_decap_8
XFILLER_14_596 VPWR VGND sg13g2_fill_1
XFILLER_6_762 VPWR VGND sg13g2_decap_8
X_2520_ net389 VPWR _0912_ VGND net488 net299 sg13g2_o21ai_1
X_2451_ VGND VPWR falutop.i2c_inst.result\[9\] _0846_ _0875_ net379 sg13g2_a21oi_1
XFILLER_5_294 VPWR VGND sg13g2_fill_1
X_2382_ net379 net380 net381 _0829_ VPWR VGND sg13g2_nor3_1
XFILLER_49_482 VPWR VGND sg13g2_decap_8
XFILLER_37_666 VPWR VGND sg13g2_decap_8
XFILLER_37_644 VPWR VGND sg13g2_fill_1
XFILLER_37_699 VPWR VGND sg13g2_decap_8
XFILLER_20_533 VPWR VGND sg13g2_decap_8
XFILLER_32_382 VPWR VGND sg13g2_decap_8
XFILLER_20_566 VPWR VGND sg13g2_decap_8
X_2718_ _1052_ VPWR _1105_ VGND _1053_ _1054_ sg13g2_o21ai_1
XFILLER_10_25 VPWR VGND sg13g2_decap_8
X_2649_ VGND VPWR _0921_ _1016_ _1038_ net306 sg13g2_a21oi_1
XFILLER_0_938 VPWR VGND sg13g2_decap_8
XFILLER_19_23 VPWR VGND sg13g2_decap_8
XFILLER_28_611 VPWR VGND sg13g2_decap_8
XFILLER_28_644 VPWR VGND sg13g2_decap_8
XFILLER_27_165 VPWR VGND sg13g2_decap_8
XFILLER_35_33 VPWR VGND sg13g2_fill_2
XFILLER_27_187 VPWR VGND sg13g2_fill_2
XFILLER_11_555 VPWR VGND sg13g2_decap_8
XFILLER_3_743 VPWR VGND sg13g2_decap_8
XFILLER_2_242 VPWR VGND sg13g2_decap_8
XFILLER_19_600 VPWR VGND sg13g2_decap_8
XFILLER_47_931 VPWR VGND sg13g2_decap_8
XFILLER_46_430 VPWR VGND sg13g2_decap_8
XFILLER_20_1026 VPWR VGND sg13g2_fill_2
XFILLER_18_165 VPWR VGND sg13g2_decap_8
XFILLER_19_699 VPWR VGND sg13g2_fill_1
XFILLER_34_658 VPWR VGND sg13g2_fill_2
XFILLER_21_319 VPWR VGND sg13g2_decap_8
XFILLER_15_894 VPWR VGND sg13g2_decap_8
X_1951_ net391 VPWR _0475_ VGND net439 net294 sg13g2_o21ai_1
X_1882_ _0408_ _0404_ _0405_ VPWR VGND sg13g2_xnor2_1
XFILLER_14_393 VPWR VGND sg13g2_fill_2
X_2503_ VGND VPWR _0704_ net302 _0067_ net398 sg13g2_a21oi_1
X_2434_ net416 net254 net313 _0036_ VPWR VGND sg13g2_mux2_1
XFILLER_37_0 VPWR VGND sg13g2_decap_8
X_2365_ VPWR _0015_ net401 VGND sg13g2_inv_1
XFILLER_29_419 VPWR VGND sg13g2_decap_8
XFILLER_38_931 VPWR VGND sg13g2_decap_8
X_2296_ _0701_ net374 _0758_ VPWR VGND sg13g2_nor2_1
XFILLER_49_290 VPWR VGND sg13g2_decap_8
XFILLER_2_81 VPWR VGND sg13g2_decap_8
XFILLER_37_485 VPWR VGND sg13g2_decap_8
XFILLER_24_113 VPWR VGND sg13g2_fill_1
XFILLER_36_1011 VPWR VGND sg13g2_decap_8
XFILLER_40_639 VPWR VGND sg13g2_decap_8
XFILLER_21_853 VPWR VGND sg13g2_decap_8
XFILLER_21_897 VPWR VGND sg13g2_decap_8
X_2896__163 VPWR VGND net163 sg13g2_tiehi
XFILLER_43_1004 VPWR VGND sg13g2_decap_8
XFILLER_0_735 VPWR VGND sg13g2_decap_8
XFILLER_48_728 VPWR VGND sg13g2_decap_8
XFILLER_47_205 VPWR VGND sg13g2_decap_8
XFILLER_46_21 VPWR VGND sg13g2_decap_8
XFILLER_29_953 VPWR VGND sg13g2_decap_8
XFILLER_44_923 VPWR VGND sg13g2_decap_8
XFILLER_16_614 VPWR VGND sg13g2_fill_1
XFILLER_16_625 VPWR VGND sg13g2_decap_8
XFILLER_43_477 VPWR VGND sg13g2_decap_8
XFILLER_15_157 VPWR VGND sg13g2_decap_8
XFILLER_24_680 VPWR VGND sg13g2_decap_8
XFILLER_12_864 VPWR VGND sg13g2_decap_8
XFILLER_23_190 VPWR VGND sg13g2_decap_4
XFILLER_8_824 VPWR VGND sg13g2_decap_8
Xclkbuf_5_31__f_clk clknet_4_15_0_clk clknet_5_31__leaf_clk VPWR VGND sg13g2_buf_8
XFILLER_3_540 VPWR VGND sg13g2_decap_8
X_2912__119 VPWR VGND net119 sg13g2_tiehi
X_2150_ _0642_ falutop.data_in\[3\] _0641_ VPWR VGND sg13g2_xnor2_1
XFILLER_4_1020 VPWR VGND sg13g2_decap_8
X_2081_ _0601_ _0600_ net370 net289 net419 VPWR VGND sg13g2_a22oi_1
XFILLER_19_463 VPWR VGND sg13g2_decap_8
XFILLER_35_934 VPWR VGND sg13g2_decap_8
XFILLER_34_455 VPWR VGND sg13g2_decap_8
XFILLER_15_691 VPWR VGND sg13g2_decap_8
XFILLER_21_116 VPWR VGND sg13g2_decap_8
X_1934_ _0458_ _0437_ _0459_ VPWR VGND sg13g2_xor2_1
XFILLER_21_149 VPWR VGND sg13g2_decap_8
X_1865_ _0390_ _0391_ _0088_ VPWR VGND sg13g2_nor2_1
X_1796_ _0323_ _0272_ _0324_ VPWR VGND sg13g2_xor2_1
X_2417_ _0858_ VPWR _0026_ VGND net408 _0855_ sg13g2_o21ai_1
X_2348_ _0804_ net269 _0803_ VPWR VGND sg13g2_nand2_1
XFILLER_45_709 VPWR VGND sg13g2_decap_8
X_2279_ VGND VPWR net275 _0744_ _0001_ _0745_ sg13g2_a21oi_1
XFILLER_44_208 VPWR VGND sg13g2_fill_2
XFILLER_37_260 VPWR VGND sg13g2_decap_8
XFILLER_26_923 VPWR VGND sg13g2_decap_8
XFILLER_16_13 VPWR VGND sg13g2_decap_8
XFILLER_13_606 VPWR VGND sg13g2_decap_8
XFILLER_40_414 VPWR VGND sg13g2_decap_8
XFILLER_12_127 VPWR VGND sg13g2_fill_1
XFILLER_21_683 VPWR VGND sg13g2_decap_8
XFILLER_32_34 VPWR VGND sg13g2_decap_4
XFILLER_5_805 VPWR VGND sg13g2_decap_8
XFILLER_0_532 VPWR VGND sg13g2_decap_8
XFILLER_44_720 VPWR VGND sg13g2_fill_2
XFILLER_17_945 VPWR VGND sg13g2_decap_8
XFILLER_29_794 VPWR VGND sg13g2_decap_8
XFILLER_16_466 VPWR VGND sg13g2_decap_4
XFILLER_44_786 VPWR VGND sg13g2_decap_8
XFILLER_32_937 VPWR VGND sg13g2_decap_8
XFILLER_8_621 VPWR VGND sg13g2_decap_8
XFILLER_8_698 VPWR VGND sg13g2_decap_8
XFILLER_7_153 VPWR VGND sg13g2_decap_8
XFILLER_11_193 VPWR VGND sg13g2_decap_4
X_1650_ _0151_ _0179_ _0148_ _0180_ VPWR VGND sg13g2_nand3_1
Xhold109 falutop.i2c_inst.data_in\[7\] VPWR VGND net410 sg13g2_dlygate4sd3_1
X_1581_ _1281_ _1280_ _1239_ VPWR VGND sg13g2_nand2b_1
XFILLER_26_1021 VPWR VGND sg13g2_decap_8
X_2202_ VGND VPWR net383 _0678_ _0137_ _0679_ sg13g2_a21oi_1
XFILLER_39_569 VPWR VGND sg13g2_decap_8
X_2133_ _0630_ net180 net290 VPWR VGND sg13g2_nand2_1
X_2064_ _0561_ _0522_ _0585_ VPWR VGND sg13g2_xor2_1
XFILLER_19_282 VPWR VGND sg13g2_decap_4
XFILLER_34_263 VPWR VGND sg13g2_decap_8
X_2897_ net161 VGND VPWR net181 falutop.div_inst.a\[5\] clknet_5_5__leaf_clk sg13g2_dfrbpq_1
X_1917_ _0442_ net352 net320 net355 net316 VPWR VGND sg13g2_a22oi_1
X_1848_ _0373_ _0346_ _0375_ VPWR VGND sg13g2_xor2_1
X_1779_ net362 _0261_ net321 _0307_ VPWR VGND sg13g2_nand3_1
XFILLER_1_329 VPWR VGND sg13g2_decap_8
XFILLER_27_45 VPWR VGND sg13g2_decap_8
XFILLER_41_734 VPWR VGND sg13g2_fill_2
XFILLER_41_723 VPWR VGND sg13g2_decap_8
XFILLER_13_414 VPWR VGND sg13g2_fill_2
XFILLER_14_948 VPWR VGND sg13g2_decap_8
XFILLER_26_797 VPWR VGND sg13g2_decap_8
XFILLER_41_767 VPWR VGND sg13g2_fill_1
XFILLER_41_756 VPWR VGND sg13g2_decap_8
XFILLER_13_458 VPWR VGND sg13g2_decap_8
XFILLER_43_77 VPWR VGND sg13g2_decap_8
XFILLER_5_602 VPWR VGND sg13g2_decap_8
XFILLER_4_123 VPWR VGND sg13g2_decap_8
XFILLER_49_1021 VPWR VGND sg13g2_decap_8
XFILLER_5_679 VPWR VGND sg13g2_decap_8
XFILLER_1_896 VPWR VGND sg13g2_decap_8
XFILLER_49_867 VPWR VGND sg13g2_decap_8
XFILLER_48_333 VPWR VGND sg13g2_decap_4
XFILLER_48_322 VPWR VGND sg13g2_fill_1
XFILLER_48_366 VPWR VGND sg13g2_decap_8
XFILLER_1_1001 VPWR VGND sg13g2_decap_8
XFILLER_29_580 VPWR VGND sg13g2_decap_4
XFILLER_36_539 VPWR VGND sg13g2_decap_8
XFILLER_17_753 VPWR VGND sg13g2_decap_8
XFILLER_44_583 VPWR VGND sg13g2_decap_8
XFILLER_44_561 VPWR VGND sg13g2_decap_8
XFILLER_44_594 VPWR VGND sg13g2_fill_1
XFILLER_20_907 VPWR VGND sg13g2_decap_8
XFILLER_32_767 VPWR VGND sg13g2_decap_8
XFILLER_32_778 VPWR VGND sg13g2_fill_1
X_2820_ net50 VGND VPWR net449 falutop.data_in\[13\] clknet_5_13__leaf_clk sg13g2_dfrbpq_2
XFILLER_13_992 VPWR VGND sg13g2_decap_8
X_2751_ VGND VPWR _0988_ _1022_ _1138_ _1020_ sg13g2_a21oi_1
XFILLER_31_288 VPWR VGND sg13g2_decap_4
XFILLER_9_985 VPWR VGND sg13g2_decap_8
X_2682_ VGND VPWR _0718_ net274 _1070_ _1069_ sg13g2_a21oi_1
X_1702_ _0217_ _0230_ _0182_ _0232_ VPWR VGND _0231_ sg13g2_nand4_1
X_1633_ _0152_ _0154_ _0163_ _0164_ VPWR VGND sg13g2_nor3_1
X_1564_ VPWR VGND _0937_ _1264_ _1080_ _0935_ _1265_ _1017_ sg13g2_a221oi_1
X_1495_ net317 net358 net344 _1197_ VPWR VGND sg13g2_nand3_1
XFILLER_39_300 VPWR VGND sg13g2_decap_4
X_3096_ falutop.i2c_inst.sda_o net4 VPWR VGND sg13g2_buf_8
X_2116_ _0617_ net371 falutop.data_in\[8\] VPWR VGND sg13g2_nand2_1
XFILLER_27_539 VPWR VGND sg13g2_decap_8
X_2047_ _0537_ VPWR _0569_ VGND _0519_ _0535_ sg13g2_o21ai_1
XFILLER_35_561 VPWR VGND sg13g2_fill_1
XFILLER_35_572 VPWR VGND sg13g2_decap_8
XFILLER_35_583 VPWR VGND sg13g2_fill_1
XFILLER_23_734 VPWR VGND sg13g2_decap_4
XFILLER_23_778 VPWR VGND sg13g2_decap_8
XFILLER_13_47 VPWR VGND sg13g2_fill_1
XFILLER_2_627 VPWR VGND sg13g2_decap_8
XFILLER_1_126 VPWR VGND sg13g2_decap_8
XFILLER_38_11 VPWR VGND sg13g2_fill_1
XFILLER_38_44 VPWR VGND sg13g2_decap_8
XFILLER_38_66 VPWR VGND sg13g2_fill_2
XFILLER_38_55 VPWR VGND sg13g2_fill_1
XFILLER_46_848 VPWR VGND sg13g2_decap_8
XFILLER_14_756 VPWR VGND sg13g2_decap_8
XFILLER_41_564 VPWR VGND sg13g2_decap_4
XFILLER_6_944 VPWR VGND sg13g2_decap_8
XFILLER_10_984 VPWR VGND sg13g2_decap_8
XFILLER_5_476 VPWR VGND sg13g2_decap_8
XFILLER_1_693 VPWR VGND sg13g2_decap_8
XFILLER_23_1002 VPWR VGND sg13g2_decap_8
XFILLER_49_664 VPWR VGND sg13g2_decap_8
XFILLER_37_859 VPWR VGND sg13g2_decap_8
X_2828__40 VPWR VGND net40 sg13g2_tiehi
XFILLER_20_704 VPWR VGND sg13g2_fill_1
X_2803_ net70 VGND VPWR _0024_ falutop.i2c_inst.counter\[2\] clknet_5_26__leaf_clk
+ sg13g2_dfrbpq_2
XFILLER_9_782 VPWR VGND sg13g2_decap_8
X_2734_ _1121_ _1078_ _1120_ VPWR VGND sg13g2_nand2_2
X_2665_ VGND VPWR _1053_ _1051_ _1050_ sg13g2_or2_1
X_2596_ VGND VPWR _0982_ _0985_ _0984_ _0983_ sg13g2_a21oi_2
X_1616_ _1225_ VPWR _0147_ VGND _1214_ _1226_ sg13g2_o21ai_1
XFILLER_5_81 VPWR VGND sg13g2_decap_4
X_1547_ VGND VPWR _0920_ _0935_ _1248_ _1247_ sg13g2_a21oi_1
X_1478_ _1180_ _0925_ _1080_ VPWR VGND sg13g2_nand2_1
XFILLER_39_185 VPWR VGND sg13g2_decap_8
XFILLER_27_325 VPWR VGND sg13g2_decap_8
XFILLER_28_848 VPWR VGND sg13g2_decap_8
XFILLER_15_509 VPWR VGND sg13g2_decap_8
XFILLER_27_369 VPWR VGND sg13g2_fill_1
X_2819__51 VPWR VGND net51 sg13g2_tiehi
XFILLER_43_829 VPWR VGND sg13g2_decap_8
XFILLER_36_892 VPWR VGND sg13g2_decap_8
XFILLER_23_575 VPWR VGND sg13g2_decap_8
XFILLER_11_748 VPWR VGND sg13g2_decap_8
XFILLER_3_925 VPWR VGND sg13g2_decap_8
XFILLER_49_21 VPWR VGND sg13g2_decap_8
XFILLER_46_1002 VPWR VGND sg13g2_decap_8
XFILLER_6_4 VPWR VGND sg13g2_decap_8
XFILLER_2_424 VPWR VGND sg13g2_decap_8
XFILLER_1_28 VPWR VGND sg13g2_decap_8
XFILLER_19_804 VPWR VGND sg13g2_decap_8
XFILLER_46_623 VPWR VGND sg13g2_decap_8
XFILLER_18_358 VPWR VGND sg13g2_fill_2
XFILLER_18_369 VPWR VGND sg13g2_decap_8
X_2825__43 VPWR VGND net43 sg13g2_tiehi
XFILLER_45_188 VPWR VGND sg13g2_decap_8
XFILLER_42_884 VPWR VGND sg13g2_decap_8
XFILLER_41_350 VPWR VGND sg13g2_fill_1
X_2908__135 VPWR VGND net135 sg13g2_tiehi
XFILLER_14_553 VPWR VGND sg13g2_decap_4
XFILLER_10_781 VPWR VGND sg13g2_decap_8
XFILLER_6_741 VPWR VGND sg13g2_decap_8
X_2450_ _0869_ _0873_ _0874_ VPWR VGND falutop.i2c_inst.counter\[3\] sg13g2_nand3b_1
X_2381_ net380 net381 _0828_ VPWR VGND sg13g2_nor2_1
XFILLER_2_991 VPWR VGND sg13g2_decap_8
XFILLER_37_601 VPWR VGND sg13g2_decap_8
XFILLER_1_490 VPWR VGND sg13g2_decap_8
XFILLER_49_461 VPWR VGND sg13g2_fill_2
XFILLER_24_306 VPWR VGND sg13g2_fill_1
XFILLER_25_829 VPWR VGND sg13g2_decap_8
X_2816__54 VPWR VGND net54 sg13g2_tiehi
X_2717_ VGND VPWR _1104_ _1102_ net306 sg13g2_or2_1
X_2648_ net309 VPWR _1037_ VGND _1017_ net280 sg13g2_o21ai_1
XFILLER_0_917 VPWR VGND sg13g2_decap_8
X_2579_ VGND VPWR _0964_ _0967_ _0968_ _0925_ sg13g2_a21oi_1
XFILLER_19_46 VPWR VGND sg13g2_fill_1
XFILLER_15_306 VPWR VGND sg13g2_decap_8
XFILLER_16_818 VPWR VGND sg13g2_fill_2
XFILLER_35_23 VPWR VGND sg13g2_fill_1
XFILLER_23_350 VPWR VGND sg13g2_fill_2
XFILLER_24_851 VPWR VGND sg13g2_fill_2
XFILLER_24_873 VPWR VGND sg13g2_decap_4
XFILLER_23_361 VPWR VGND sg13g2_decap_8
XFILLER_24_884 VPWR VGND sg13g2_decap_8
XFILLER_24_895 VPWR VGND sg13g2_fill_2
XFILLER_11_534 VPWR VGND sg13g2_decap_8
XFILLER_7_549 VPWR VGND sg13g2_decap_8
XFILLER_3_722 VPWR VGND sg13g2_decap_8
XFILLER_2_221 VPWR VGND sg13g2_decap_8
XFILLER_3_799 VPWR VGND sg13g2_decap_8
XFILLER_2_298 VPWR VGND sg13g2_decap_8
XFILLER_47_910 VPWR VGND sg13g2_decap_8
XFILLER_19_656 VPWR VGND sg13g2_decap_8
XFILLER_20_1005 VPWR VGND sg13g2_decap_8
XFILLER_47_987 VPWR VGND sg13g2_decap_8
XFILLER_19_678 VPWR VGND sg13g2_decap_8
XFILLER_15_873 VPWR VGND sg13g2_decap_8
X_2813__57 VPWR VGND net57 sg13g2_tiehi
X_1950_ VGND VPWR _0471_ _0474_ _0090_ _0436_ sg13g2_a21oi_1
XFILLER_41_191 VPWR VGND sg13g2_decap_8
X_1881_ VGND VPWR net316 net359 _0407_ _0405_ sg13g2_a21oi_1
XFILLER_30_865 VPWR VGND sg13g2_decap_8
X_2502_ net390 VPWR _0903_ VGND net397 net302 sg13g2_o21ai_1
X_2433_ net410 net373 net312 _0035_ VPWR VGND sg13g2_mux2_1
X_2364_ _0817_ _0815_ _0730_ net277 net400 VPWR VGND sg13g2_a22oi_1
XFILLER_38_910 VPWR VGND sg13g2_decap_8
X_2295_ VGND VPWR net276 _0756_ _0005_ _0757_ sg13g2_a21oi_1
XFILLER_2_60 VPWR VGND sg13g2_decap_8
XFILLER_37_420 VPWR VGND sg13g2_fill_2
XFILLER_38_987 VPWR VGND sg13g2_decap_8
XFILLER_12_309 VPWR VGND sg13g2_decap_8
XFILLER_21_832 VPWR VGND sg13g2_decap_8
XFILLER_33_670 VPWR VGND sg13g2_decap_4
XFILLER_33_692 VPWR VGND sg13g2_decap_4
X_2804__68 VPWR VGND net68 sg13g2_tiehi
XFILLER_20_320 VPWR VGND sg13g2_fill_2
XFILLER_0_714 VPWR VGND sg13g2_decap_8
XFILLER_29_932 VPWR VGND sg13g2_decap_8
XFILLER_28_431 VPWR VGND sg13g2_fill_1
XFILLER_46_77 VPWR VGND sg13g2_fill_2
XFILLER_46_44 VPWR VGND sg13g2_decap_8
XFILLER_44_902 VPWR VGND sg13g2_decap_8
XFILLER_46_99 VPWR VGND sg13g2_decap_8
XFILLER_44_979 VPWR VGND sg13g2_decap_8
XFILLER_43_445 VPWR VGND sg13g2_fill_2
XFILLER_8_803 VPWR VGND sg13g2_decap_8
XFILLER_12_843 VPWR VGND sg13g2_decap_8
XFILLER_11_353 VPWR VGND sg13g2_decap_8
XFILLER_7_49 VPWR VGND sg13g2_decap_8
XFILLER_11_91 VPWR VGND sg13g2_decap_8
XFILLER_3_596 VPWR VGND sg13g2_decap_8
Xclkbuf_4_9_0_clk clknet_0_clk clknet_4_9_0_clk VPWR VGND sg13g2_buf_8
X_2080_ falutop.data_in\[14\] net289 _0599_ _0600_ VPWR VGND sg13g2_nor3_1
XFILLER_47_784 VPWR VGND sg13g2_decap_8
XFILLER_35_913 VPWR VGND sg13g2_decap_8
XFILLER_43_990 VPWR VGND sg13g2_decap_8
XFILLER_22_629 VPWR VGND sg13g2_decap_8
X_1933_ _0458_ _0440_ _0457_ VPWR VGND sg13g2_xnor2_1
XFILLER_21_139 VPWR VGND sg13g2_fill_1
X_1864_ net393 VPWR _0391_ VGND net443 net294 sg13g2_o21ai_1
X_1795_ _0323_ _0320_ _0321_ VPWR VGND sg13g2_xnor2_1
XFILLER_6_390 VPWR VGND sg13g2_fill_1
X_2416_ _0856_ net297 _0857_ _0858_ VPWR VGND sg13g2_a21o_1
X_2347_ _0803_ _0778_ _0779_ VPWR VGND sg13g2_xnor2_1
X_2278_ net195 net275 _0745_ VPWR VGND sg13g2_nor2_1
XFILLER_29_239 VPWR VGND sg13g2_decap_8
XFILLER_26_902 VPWR VGND sg13g2_decap_8
XFILLER_26_979 VPWR VGND sg13g2_decap_8
XFILLER_41_949 VPWR VGND sg13g2_decap_8
XFILLER_40_437 VPWR VGND sg13g2_fill_1
XFILLER_21_662 VPWR VGND sg13g2_decap_8
XFILLER_10_1026 VPWR VGND sg13g2_fill_2
XFILLER_0_511 VPWR VGND sg13g2_decap_8
XFILLER_0_588 VPWR VGND sg13g2_decap_8
XFILLER_48_537 VPWR VGND sg13g2_decap_8
XFILLER_29_740 VPWR VGND sg13g2_decap_8
XFILLER_29_773 VPWR VGND sg13g2_decap_8
XFILLER_16_401 VPWR VGND sg13g2_decap_8
XFILLER_17_924 VPWR VGND sg13g2_decap_8
XFILLER_16_445 VPWR VGND sg13g2_decap_8
XFILLER_32_916 VPWR VGND sg13g2_decap_8
XFILLER_40_982 VPWR VGND sg13g2_decap_8
XFILLER_8_600 VPWR VGND sg13g2_decap_8
XFILLER_12_684 VPWR VGND sg13g2_decap_8
XFILLER_8_677 VPWR VGND sg13g2_decap_8
XFILLER_22_90 VPWR VGND sg13g2_decap_8
X_1580_ _1280_ _1246_ _1278_ VPWR VGND sg13g2_xnor2_1
XFILLER_4_894 VPWR VGND sg13g2_decap_8
XFILLER_3_393 VPWR VGND sg13g2_decap_8
XFILLER_26_1000 VPWR VGND sg13g2_decap_8
XFILLER_21_4 VPWR VGND sg13g2_fill_2
X_2201_ net391 VPWR _0679_ VGND net244 _0678_ sg13g2_o21ai_1
XFILLER_39_548 VPWR VGND sg13g2_decap_8
X_2132_ _0629_ falutop.data_in\[13\] _0628_ VPWR VGND sg13g2_xnor2_1
XFILLER_19_250 VPWR VGND sg13g2_fill_2
X_2063_ _0563_ VPWR _0584_ VGND _0523_ _0564_ sg13g2_o21ai_1
XFILLER_19_261 VPWR VGND sg13g2_decap_8
XFILLER_34_220 VPWR VGND sg13g2_decap_8
XFILLER_35_776 VPWR VGND sg13g2_decap_8
XFILLER_33_1015 VPWR VGND sg13g2_decap_8
X_1916_ _0411_ _0401_ _0410_ _0441_ VPWR VGND sg13g2_a21o_1
X_2896_ net163 VGND VPWR net206 falutop.div_inst.a\[4\] clknet_5_5__leaf_clk sg13g2_dfrbpq_1
XFILLER_30_492 VPWR VGND sg13g2_decap_8
X_1847_ _0374_ _0346_ _0373_ VPWR VGND sg13g2_nand2b_1
XFILLER_8_81 VPWR VGND sg13g2_decap_8
X_1778_ VGND VPWR net320 net362 _0306_ _0261_ sg13g2_a21oi_1
XFILLER_2_809 VPWR VGND sg13g2_decap_8
XFILLER_1_308 VPWR VGND sg13g2_decap_8
XFILLER_27_35 VPWR VGND sg13g2_decap_4
XFILLER_38_581 VPWR VGND sg13g2_fill_1
XFILLER_27_79 VPWR VGND sg13g2_decap_8
XFILLER_41_702 VPWR VGND sg13g2_decap_8
XFILLER_14_927 VPWR VGND sg13g2_decap_8
XFILLER_43_56 VPWR VGND sg13g2_decap_8
XFILLER_13_426 VPWR VGND sg13g2_decap_8
XFILLER_40_289 VPWR VGND sg13g2_fill_2
XFILLER_49_1000 VPWR VGND sg13g2_decap_8
XFILLER_4_102 VPWR VGND sg13g2_decap_8
XFILLER_5_658 VPWR VGND sg13g2_decap_8
XFILLER_4_179 VPWR VGND sg13g2_decap_8
XFILLER_4_39 VPWR VGND sg13g2_decap_8
XFILLER_1_875 VPWR VGND sg13g2_decap_8
XFILLER_49_846 VPWR VGND sg13g2_decap_8
XFILLER_0_385 VPWR VGND sg13g2_decap_8
XFILLER_17_710 VPWR VGND sg13g2_fill_2
XFILLER_17_732 VPWR VGND sg13g2_decap_8
XFILLER_16_264 VPWR VGND sg13g2_decap_8
XFILLER_17_787 VPWR VGND sg13g2_fill_2
XFILLER_31_223 VPWR VGND sg13g2_decap_8
XFILLER_32_746 VPWR VGND sg13g2_decap_8
XFILLER_13_971 VPWR VGND sg13g2_decap_8
XFILLER_31_267 VPWR VGND sg13g2_decap_8
X_2750_ _1137_ _1033_ _0986_ VPWR VGND sg13g2_nand2b_1
XFILLER_9_964 VPWR VGND sg13g2_decap_8
X_2681_ net338 net274 _1069_ VPWR VGND sg13g2_nor2_1
X_1701_ _0231_ _0221_ _1088_ _0219_ net283 VPWR VGND sg13g2_a22oi_1
X_1632_ _0161_ _0162_ _0160_ _0163_ VPWR VGND sg13g2_nand3_1
X_1563_ _0937_ _1013_ _1264_ VPWR VGND sg13g2_nor2_1
XFILLER_4_691 VPWR VGND sg13g2_decap_8
X_1494_ _1196_ net339 net321 VPWR VGND sg13g2_nand2_1
XFILLER_27_507 VPWR VGND sg13g2_decap_8
XFILLER_27_518 VPWR VGND sg13g2_fill_1
XFILLER_39_389 VPWR VGND sg13g2_fill_2
XFILLER_39_378 VPWR VGND sg13g2_decap_8
X_2115_ _0616_ net178 net290 VPWR VGND sg13g2_nand2_1
X_2046_ _0568_ _0521_ _0567_ VPWR VGND sg13g2_xnor2_1
XFILLER_22_289 VPWR VGND sg13g2_decap_4
X_2879_ net85 VGND VPWR net491 falutop.alu_data_in\[3\] clknet_5_13__leaf_clk sg13g2_dfrbpq_2
XFILLER_2_606 VPWR VGND sg13g2_decap_8
XFILLER_1_105 VPWR VGND sg13g2_decap_8
XFILLER_38_23 VPWR VGND sg13g2_decap_8
XFILLER_46_827 VPWR VGND sg13g2_decap_8
XFILLER_26_573 VPWR VGND sg13g2_fill_1
XFILLER_13_234 VPWR VGND sg13g2_decap_4
XFILLER_9_205 VPWR VGND sg13g2_decap_8
XFILLER_14_768 VPWR VGND sg13g2_decap_8
XFILLER_9_227 VPWR VGND sg13g2_decap_8
XFILLER_10_963 VPWR VGND sg13g2_decap_8
XFILLER_6_923 VPWR VGND sg13g2_decap_8
XFILLER_5_455 VPWR VGND sg13g2_decap_8
XFILLER_49_643 VPWR VGND sg13g2_decap_8
XFILLER_1_672 VPWR VGND sg13g2_decap_8
XFILLER_37_805 VPWR VGND sg13g2_decap_8
XFILLER_0_182 VPWR VGND sg13g2_decap_8
XFILLER_45_882 VPWR VGND sg13g2_decap_8
XFILLER_17_562 VPWR VGND sg13g2_decap_4
XFILLER_44_381 VPWR VGND sg13g2_fill_2
XFILLER_44_370 VPWR VGND sg13g2_decap_8
XFILLER_32_543 VPWR VGND sg13g2_fill_1
XFILLER_32_576 VPWR VGND sg13g2_decap_4
X_2924__141 VPWR VGND net141 sg13g2_tiehi
X_2802_ net72 VGND VPWR _0023_ falutop.i2c_inst.counter\[1\] clknet_5_25__leaf_clk
+ sg13g2_dfrbpq_2
XFILLER_9_761 VPWR VGND sg13g2_decap_8
X_2733_ _1119_ _1110_ _1120_ VPWR VGND sg13g2_xor2_1
XFILLER_8_293 VPWR VGND sg13g2_fill_1
X_2664_ VPWR _1052_ _1051_ VGND sg13g2_inv_1
X_2595_ net323 net327 _0984_ VPWR VGND sg13g2_nor2_2
X_1615_ _1313_ _1305_ _1315_ VPWR VGND sg13g2_xor2_1
XFILLER_5_60 VPWR VGND sg13g2_decap_8
X_1546_ _1247_ net354 net345 net367 net329 VPWR VGND sg13g2_a22oi_1
X_1477_ VGND VPWR _1013_ _1178_ _1179_ _0925_ sg13g2_a21oi_1
XFILLER_39_153 VPWR VGND sg13g2_decap_4
XFILLER_43_808 VPWR VGND sg13g2_decap_8
XFILLER_39_1010 VPWR VGND sg13g2_decap_8
X_2029_ _0552_ net370 _0516_ VPWR VGND sg13g2_nand2_1
XFILLER_24_58 VPWR VGND sg13g2_decap_8
XFILLER_11_727 VPWR VGND sg13g2_decap_8
XFILLER_40_46 VPWR VGND sg13g2_fill_2
XFILLER_3_904 VPWR VGND sg13g2_decap_8
XFILLER_2_403 VPWR VGND sg13g2_decap_8
XFILLER_49_88 VPWR VGND sg13g2_decap_8
XFILLER_46_602 VPWR VGND sg13g2_decap_8
XFILLER_18_337 VPWR VGND sg13g2_fill_2
XFILLER_34_808 VPWR VGND sg13g2_decap_4
XFILLER_45_178 VPWR VGND sg13g2_fill_1
XFILLER_27_882 VPWR VGND sg13g2_decap_8
XFILLER_14_532 VPWR VGND sg13g2_fill_2
XFILLER_42_863 VPWR VGND sg13g2_decap_8
XFILLER_14_587 VPWR VGND sg13g2_decap_8
XFILLER_6_720 VPWR VGND sg13g2_decap_8
XFILLER_10_760 VPWR VGND sg13g2_decap_8
XFILLER_5_230 VPWR VGND sg13g2_decap_8
XFILLER_6_797 VPWR VGND sg13g2_decap_8
Xclkbuf_5_14__f_clk clknet_4_7_0_clk clknet_5_14__leaf_clk VPWR VGND sg13g2_buf_8
X_2380_ net2 _0826_ net1 _0827_ VPWR VGND sg13g2_nand3_1
XFILLER_2_970 VPWR VGND sg13g2_decap_8
X_2915__107 VPWR VGND net107 sg13g2_tiehi
XFILLER_49_440 VPWR VGND sg13g2_decap_8
XFILLER_37_613 VPWR VGND sg13g2_fill_2
X_2850__154 VPWR VGND net154 sg13g2_tiehi
XFILLER_37_635 VPWR VGND sg13g2_decap_8
XFILLER_36_134 VPWR VGND sg13g2_decap_8
XFILLER_18_860 VPWR VGND sg13g2_decap_8
XFILLER_17_370 VPWR VGND sg13g2_decap_8
XFILLER_36_189 VPWR VGND sg13g2_decap_8
X_2831__36 VPWR VGND net36 sg13g2_tiehi
XFILLER_33_896 VPWR VGND sg13g2_decap_8
XFILLER_32_395 VPWR VGND sg13g2_decap_8
X_2716_ net306 _1102_ _1103_ VPWR VGND sg13g2_nor2_1
X_2647_ VGND VPWR _1034_ _1035_ _1036_ _1030_ sg13g2_a21oi_1
X_2578_ _0966_ _0965_ _0929_ _0967_ VPWR VGND sg13g2_a21o_2
X_1529_ _1230_ _1228_ _1229_ VPWR VGND sg13g2_nand2_1
XFILLER_27_101 VPWR VGND sg13g2_decap_8
XFILLER_28_624 VPWR VGND sg13g2_decap_4
XFILLER_27_112 VPWR VGND sg13g2_decap_8
XFILLER_43_616 VPWR VGND sg13g2_fill_2
XFILLER_43_605 VPWR VGND sg13g2_decap_8
XFILLER_43_649 VPWR VGND sg13g2_fill_2
XFILLER_24_830 VPWR VGND sg13g2_decap_4
XFILLER_35_46 VPWR VGND sg13g2_decap_4
XFILLER_23_395 VPWR VGND sg13g2_fill_2
XFILLER_7_528 VPWR VGND sg13g2_decap_8
XFILLER_13_1013 VPWR VGND sg13g2_decap_8
XFILLER_3_701 VPWR VGND sg13g2_decap_8
XFILLER_2_200 VPWR VGND sg13g2_decap_8
XFILLER_3_778 VPWR VGND sg13g2_decap_8
XFILLER_2_277 VPWR VGND sg13g2_decap_8
XFILLER_47_966 VPWR VGND sg13g2_decap_8
XFILLER_18_112 VPWR VGND sg13g2_fill_2
XFILLER_19_635 VPWR VGND sg13g2_decap_8
XFILLER_20_1028 VPWR VGND sg13g2_fill_1
XFILLER_46_487 VPWR VGND sg13g2_fill_2
XFILLER_18_189 VPWR VGND sg13g2_fill_2
XFILLER_15_852 VPWR VGND sg13g2_decap_8
XFILLER_33_148 VPWR VGND sg13g2_decap_8
XFILLER_33_159 VPWR VGND sg13g2_fill_2
XFILLER_42_693 VPWR VGND sg13g2_decap_8
X_1880_ _0406_ _0405_ _0404_ VPWR VGND sg13g2_nand2b_1
XFILLER_30_844 VPWR VGND sg13g2_decap_4
XFILLER_10_590 VPWR VGND sg13g2_decap_8
X_2501_ VGND VPWR _0705_ net301 _0066_ _0902_ sg13g2_a21oi_1
XFILLER_6_594 VPWR VGND sg13g2_decap_8
X_2432_ net423 falutop.data_in\[6\] net311 _0034_ VPWR VGND sg13g2_mux2_1
X_2363_ VPWR _0816_ _0815_ VGND sg13g2_inv_1
X_2294_ net188 net276 _0757_ VPWR VGND sg13g2_nor2_1
XFILLER_38_966 VPWR VGND sg13g2_decap_8
XFILLER_37_465 VPWR VGND sg13g2_decap_8
XFILLER_25_627 VPWR VGND sg13g2_fill_2
XFILLER_24_137 VPWR VGND sg13g2_decap_8
XFILLER_20_376 VPWR VGND sg13g2_fill_2
XFILLER_4_509 VPWR VGND sg13g2_decap_8
XFILLER_21_48 VPWR VGND sg13g2_decap_8
XFILLER_48_708 VPWR VGND sg13g2_fill_2
XFILLER_29_911 VPWR VGND sg13g2_decap_8
XFILLER_47_229 VPWR VGND sg13g2_decap_8
XFILLER_28_410 VPWR VGND sg13g2_decap_8
XFILLER_29_988 VPWR VGND sg13g2_decap_8
XFILLER_44_958 VPWR VGND sg13g2_decap_8
XFILLER_43_424 VPWR VGND sg13g2_decap_8
XFILLER_12_822 VPWR VGND sg13g2_decap_8
XFILLER_30_129 VPWR VGND sg13g2_decap_4
XFILLER_7_314 VPWR VGND sg13g2_decap_8
XFILLER_7_28 VPWR VGND sg13g2_decap_8
XFILLER_12_899 VPWR VGND sg13g2_decap_8
XFILLER_8_859 VPWR VGND sg13g2_decap_8
XFILLER_3_575 VPWR VGND sg13g2_decap_8
XFILLER_39_719 VPWR VGND sg13g2_decap_8
XFILLER_38_218 VPWR VGND sg13g2_fill_2
XFILLER_19_421 VPWR VGND sg13g2_decap_4
XFILLER_47_763 VPWR VGND sg13g2_decap_8
XFILLER_19_454 VPWR VGND sg13g2_decap_4
XFILLER_46_284 VPWR VGND sg13g2_decap_8
XFILLER_19_487 VPWR VGND sg13g2_decap_8
XFILLER_22_608 VPWR VGND sg13g2_decap_8
XFILLER_35_969 VPWR VGND sg13g2_decap_8
X_1932_ _0457_ _0441_ _0455_ VPWR VGND sg13g2_xnor2_1
XFILLER_30_641 VPWR VGND sg13g2_decap_8
X_2798__79 VPWR VGND net79 sg13g2_tiehi
X_1863_ VPWR VGND net305 net296 _0389_ net278 _0390_ _0387_ sg13g2_a221oi_1
XFILLER_30_696 VPWR VGND sg13g2_decap_8
X_1794_ _0320_ _0321_ _0322_ VPWR VGND sg13g2_nor2b_1
XFILLER_7_892 VPWR VGND sg13g2_decap_8
XFILLER_42_0 VPWR VGND sg13g2_fill_2
X_2415_ _0857_ falutop.i2c_inst.counter\[4\] net387 VPWR VGND sg13g2_nand2_1
X_2346_ _0802_ net262 net277 VPWR VGND sg13g2_nand2_1
XFILLER_29_218 VPWR VGND sg13g2_decap_8
XFILLER_38_730 VPWR VGND sg13g2_fill_2
X_2277_ VGND VPWR net376 net178 _0744_ _0743_ sg13g2_a21oi_1
XFILLER_38_763 VPWR VGND sg13g2_fill_2
XFILLER_26_958 VPWR VGND sg13g2_decap_8
XFILLER_37_295 VPWR VGND sg13g2_fill_2
XFILLER_41_928 VPWR VGND sg13g2_decap_8
XFILLER_40_449 VPWR VGND sg13g2_decap_8
XFILLER_32_47 VPWR VGND sg13g2_decap_4
XFILLER_20_184 VPWR VGND sg13g2_fill_2
XFILLER_32_69 VPWR VGND sg13g2_decap_8
XFILLER_10_1005 VPWR VGND sg13g2_decap_8
XFILLER_0_567 VPWR VGND sg13g2_decap_8
XFILLER_17_903 VPWR VGND sg13g2_decap_8
XFILLER_28_295 VPWR VGND sg13g2_decap_8
X_2882__75 VPWR VGND net75 sg13g2_tiehi
XFILLER_43_254 VPWR VGND sg13g2_decap_8
XFILLER_31_416 VPWR VGND sg13g2_fill_2
XFILLER_40_961 VPWR VGND sg13g2_decap_8
XFILLER_12_663 VPWR VGND sg13g2_fill_2
XFILLER_8_656 VPWR VGND sg13g2_decap_8
XFILLER_4_873 VPWR VGND sg13g2_decap_8
XFILLER_3_372 VPWR VGND sg13g2_decap_8
X_2200_ _0657_ _0675_ _0678_ VPWR VGND sg13g2_nor2_1
XFILLER_39_527 VPWR VGND sg13g2_decap_8
X_2131_ _0598_ net370 _0628_ VPWR VGND sg13g2_nor2b_1
XFILLER_14_4 VPWR VGND sg13g2_decap_8
X_2062_ _0566_ VPWR _0583_ VGND _0520_ _0567_ sg13g2_o21ai_1
XFILLER_47_571 VPWR VGND sg13g2_decap_8
XFILLER_19_295 VPWR VGND sg13g2_decap_8
XFILLER_16_980 VPWR VGND sg13g2_decap_8
XFILLER_23_939 VPWR VGND sg13g2_decap_8
XFILLER_15_490 VPWR VGND sg13g2_fill_1
XFILLER_22_449 VPWR VGND sg13g2_decap_8
XFILLER_34_298 VPWR VGND sg13g2_decap_8
X_1915_ _0440_ _0349_ _0438_ VPWR VGND sg13g2_xnor2_1
XFILLER_8_60 VPWR VGND sg13g2_decap_8
X_2895_ net165 VGND VPWR net211 falutop.div_inst.a\[3\] clknet_5_16__leaf_clk sg13g2_dfrbpq_1
XFILLER_31_983 VPWR VGND sg13g2_decap_8
X_1846_ _0371_ _0347_ _0373_ VPWR VGND sg13g2_xor2_1
X_1777_ _0273_ VPWR _0305_ VGND _0271_ _0274_ sg13g2_o21ai_1
X_2329_ _0788_ net417 _0789_ VPWR VGND sg13g2_xor2_1
XFILLER_45_508 VPWR VGND sg13g2_decap_4
XFILLER_27_14 VPWR VGND sg13g2_decap_8
XFILLER_14_906 VPWR VGND sg13g2_decap_8
XFILLER_26_755 VPWR VGND sg13g2_fill_1
XFILLER_40_202 VPWR VGND sg13g2_fill_1
XFILLER_13_416 VPWR VGND sg13g2_fill_1
XFILLER_25_243 VPWR VGND sg13g2_fill_2
XFILLER_43_35 VPWR VGND sg13g2_fill_1
XFILLER_40_224 VPWR VGND sg13g2_decap_8
Xclkbuf_4_8_0_clk clknet_0_clk clknet_4_8_0_clk VPWR VGND sg13g2_buf_8
XFILLER_40_268 VPWR VGND sg13g2_decap_8
XFILLER_40_246 VPWR VGND sg13g2_decap_8
XFILLER_21_460 VPWR VGND sg13g2_decap_8
XFILLER_21_471 VPWR VGND sg13g2_fill_1
XFILLER_22_983 VPWR VGND sg13g2_decap_8
XFILLER_5_637 VPWR VGND sg13g2_decap_8
XFILLER_4_158 VPWR VGND sg13g2_decap_8
XFILLER_4_18 VPWR VGND sg13g2_decap_8
XFILLER_1_854 VPWR VGND sg13g2_decap_8
XFILLER_49_825 VPWR VGND sg13g2_decap_8
XFILLER_0_364 VPWR VGND sg13g2_decap_8
XFILLER_16_243 VPWR VGND sg13g2_decap_8
XFILLER_17_777 VPWR VGND sg13g2_decap_4
XFILLER_32_725 VPWR VGND sg13g2_fill_1
XFILLER_31_202 VPWR VGND sg13g2_decap_8
XFILLER_13_950 VPWR VGND sg13g2_decap_8
XFILLER_40_791 VPWR VGND sg13g2_decap_8
XFILLER_8_420 VPWR VGND sg13g2_fill_2
XFILLER_9_943 VPWR VGND sg13g2_decap_8
X_2680_ _1067_ VPWR _1068_ VGND _0717_ _0990_ sg13g2_o21ai_1
X_1700_ VGND VPWR _1006_ _0223_ _0230_ _0229_ sg13g2_a21oi_1
X_1631_ _0162_ _0158_ _1006_ _0157_ _1088_ VPWR VGND sg13g2_a22oi_1
XFILLER_4_670 VPWR VGND sg13g2_decap_8
X_1562_ net306 _1261_ _1262_ _1263_ VPWR VGND sg13g2_nor3_1
X_1493_ _1114_ VPWR _1195_ VGND _1112_ _1116_ sg13g2_o21ai_1
XFILLER_39_335 VPWR VGND sg13g2_fill_2
XFILLER_39_324 VPWR VGND sg13g2_fill_1
XFILLER_39_357 VPWR VGND sg13g2_decap_8
X_2114_ net254 net212 net290 _0113_ VPWR VGND sg13g2_mux2_1
X_2045_ _0565_ _0558_ _0567_ VPWR VGND sg13g2_xor2_1
XFILLER_47_390 VPWR VGND sg13g2_decap_4
X_2925__109 VPWR VGND net109 sg13g2_tiehi
XFILLER_23_758 VPWR VGND sg13g2_decap_8
XFILLER_10_408 VPWR VGND sg13g2_decap_8
XFILLER_11_909 VPWR VGND sg13g2_decap_8
XFILLER_13_38 VPWR VGND sg13g2_decap_8
X_2860__134 VPWR VGND net134 sg13g2_tiehi
X_2878_ net87 VGND VPWR net524 falutop.alu_data_in\[2\] clknet_5_31__leaf_clk sg13g2_dfrbpq_1
X_1829_ _0325_ VPWR _0356_ VGND _0318_ _0326_ sg13g2_o21ai_1
X_2901__153 VPWR VGND net153 sg13g2_tiehi
XFILLER_46_806 VPWR VGND sg13g2_decap_8
XFILLER_18_519 VPWR VGND sg13g2_decap_8
XFILLER_39_891 VPWR VGND sg13g2_decap_8
XFILLER_26_552 VPWR VGND sg13g2_decap_8
XFILLER_41_533 VPWR VGND sg13g2_decap_4
XFILLER_13_224 VPWR VGND sg13g2_decap_4
XFILLER_14_725 VPWR VGND sg13g2_decap_4
XFILLER_26_585 VPWR VGND sg13g2_decap_8
XFILLER_13_257 VPWR VGND sg13g2_fill_2
XFILLER_41_588 VPWR VGND sg13g2_fill_2
XFILLER_13_279 VPWR VGND sg13g2_fill_2
XFILLER_16_1022 VPWR VGND sg13g2_decap_8
XFILLER_6_902 VPWR VGND sg13g2_decap_8
XFILLER_10_942 VPWR VGND sg13g2_decap_8
XFILLER_5_412 VPWR VGND sg13g2_decap_8
XFILLER_6_979 VPWR VGND sg13g2_decap_8
XFILLER_1_651 VPWR VGND sg13g2_decap_8
XFILLER_49_622 VPWR VGND sg13g2_decap_8
XFILLER_0_161 VPWR VGND sg13g2_decap_8
XFILLER_49_699 VPWR VGND sg13g2_decap_8
XFILLER_45_861 VPWR VGND sg13g2_decap_8
XFILLER_44_393 VPWR VGND sg13g2_decap_4
XFILLER_17_585 VPWR VGND sg13g2_fill_2
X_2801_ net74 VGND VPWR _0022_ falutop.i2c_inst.counter\[0\] clknet_5_24__leaf_clk
+ sg13g2_dfrbpq_2
XFILLER_9_740 VPWR VGND sg13g2_decap_8
XFILLER_12_290 VPWR VGND sg13g2_decap_4
X_2732_ _1119_ _1111_ _1117_ VPWR VGND sg13g2_xnor2_1
XFILLER_30_1008 VPWR VGND sg13g2_decap_8
X_2663_ VGND VPWR _0946_ _0948_ _1051_ _1049_ sg13g2_a21oi_1
X_2594_ _0983_ _0717_ _0718_ VPWR VGND sg13g2_nand2_1
X_1614_ _1305_ _1313_ _1314_ VPWR VGND sg13g2_nor2_1
X_1545_ _1246_ net309 _0935_ VPWR VGND sg13g2_nand2_1
X_1476_ _1178_ _1014_ net357 VPWR VGND sg13g2_nand2b_1
XFILLER_39_132 VPWR VGND sg13g2_decap_8
XFILLER_39_176 VPWR VGND sg13g2_decap_4
XFILLER_27_316 VPWR VGND sg13g2_decap_4
XFILLER_28_817 VPWR VGND sg13g2_decap_8
X_2028_ net279 VPWR _0551_ VGND _0547_ _0550_ sg13g2_o21ai_1
XFILLER_23_500 VPWR VGND sg13g2_decap_4
XFILLER_35_360 VPWR VGND sg13g2_fill_1
XFILLER_11_706 VPWR VGND sg13g2_decap_8
XFILLER_23_555 VPWR VGND sg13g2_decap_8
XFILLER_10_216 VPWR VGND sg13g2_fill_2
XFILLER_40_14 VPWR VGND sg13g2_decap_8
XFILLER_2_459 VPWR VGND sg13g2_decap_8
XFILLER_49_67 VPWR VGND sg13g2_decap_8
XFILLER_49_56 VPWR VGND sg13g2_decap_8
XFILLER_18_316 VPWR VGND sg13g2_decap_8
XFILLER_45_113 VPWR VGND sg13g2_decap_8
XFILLER_45_168 VPWR VGND sg13g2_decap_4
XFILLER_27_850 VPWR VGND sg13g2_decap_8
XFILLER_27_861 VPWR VGND sg13g2_fill_2
XFILLER_42_820 VPWR VGND sg13g2_fill_2
XFILLER_26_382 VPWR VGND sg13g2_fill_2
XFILLER_42_842 VPWR VGND sg13g2_decap_8
XFILLER_41_341 VPWR VGND sg13g2_decap_8
XFILLER_5_220 VPWR VGND sg13g2_fill_1
XFILLER_6_776 VPWR VGND sg13g2_decap_8
XFILLER_46_7 VPWR VGND sg13g2_decap_8
XFILLER_49_496 VPWR VGND sg13g2_decap_8
XFILLER_36_113 VPWR VGND sg13g2_fill_2
XFILLER_36_168 VPWR VGND sg13g2_decap_8
XFILLER_33_853 VPWR VGND sg13g2_decap_8
XFILLER_33_864 VPWR VGND sg13g2_fill_1
XFILLER_20_503 VPWR VGND sg13g2_decap_8
X_2715_ _0958_ _1000_ _1102_ VPWR VGND sg13g2_nor2_1
X_2646_ _1035_ _1029_ _1032_ _1021_ net334 VPWR VGND sg13g2_a22oi_1
XFILLER_10_39 VPWR VGND sg13g2_decap_8
X_2577_ _0934_ VPWR _0966_ VGND _0716_ net368 sg13g2_o21ai_1
X_1528_ _1204_ VPWR _1229_ VGND _1192_ _1205_ sg13g2_o21ai_1
XFILLER_19_37 VPWR VGND sg13g2_decap_8
XFILLER_28_658 VPWR VGND sg13g2_decap_8
XFILLER_35_14 VPWR VGND sg13g2_decap_8
XFILLER_42_127 VPWR VGND sg13g2_fill_1
XFILLER_24_853 VPWR VGND sg13g2_fill_1
XFILLER_35_69 VPWR VGND sg13g2_decap_8
X_2822__48 VPWR VGND net48 sg13g2_tiehi
Xclkbuf_5_20__f_clk clknet_4_10_0_clk clknet_5_20__leaf_clk VPWR VGND sg13g2_buf_8
XFILLER_7_507 VPWR VGND sg13g2_decap_8
XFILLER_11_569 VPWR VGND sg13g2_fill_1
XFILLER_3_757 VPWR VGND sg13g2_decap_8
XFILLER_2_256 VPWR VGND sg13g2_decap_8
XFILLER_19_614 VPWR VGND sg13g2_decap_8
XFILLER_47_945 VPWR VGND sg13g2_decap_8
XFILLER_18_124 VPWR VGND sg13g2_decap_4
XFILLER_46_455 VPWR VGND sg13g2_fill_2
XFILLER_18_146 VPWR VGND sg13g2_fill_2
XFILLER_15_831 VPWR VGND sg13g2_decap_8
XFILLER_18_179 VPWR VGND sg13g2_decap_4
XFILLER_33_127 VPWR VGND sg13g2_fill_2
XFILLER_34_639 VPWR VGND sg13g2_decap_8
XFILLER_14_330 VPWR VGND sg13g2_decap_8
XFILLER_42_683 VPWR VGND sg13g2_fill_2
XFILLER_14_374 VPWR VGND sg13g2_decap_8
XFILLER_30_801 VPWR VGND sg13g2_decap_8
XFILLER_30_823 VPWR VGND sg13g2_decap_8
XFILLER_30_856 VPWR VGND sg13g2_fill_1
XFILLER_30_889 VPWR VGND sg13g2_decap_8
X_2500_ net390 VPWR _0902_ VGND net235 net301 sg13g2_o21ai_1
X_2431_ net445 falutop.data_in\[5\] net311 _0033_ VPWR VGND sg13g2_mux2_1
XFILLER_6_573 VPWR VGND sg13g2_decap_8
X_2362_ _0815_ net269 _0814_ _0786_ _0715_ VPWR VGND sg13g2_a22oi_1
X_2293_ VGND VPWR net376 net180 _0756_ _0755_ sg13g2_a21oi_1
XFILLER_38_945 VPWR VGND sg13g2_decap_8
XFILLER_2_95 VPWR VGND sg13g2_decap_8
XFILLER_25_606 VPWR VGND sg13g2_decap_4
XFILLER_37_499 VPWR VGND sg13g2_decap_8
XFILLER_18_691 VPWR VGND sg13g2_decap_8
XFILLER_36_1025 VPWR VGND sg13g2_decap_4
XFILLER_20_322 VPWR VGND sg13g2_fill_1
XFILLER_32_193 VPWR VGND sg13g2_decap_8
XFILLER_21_867 VPWR VGND sg13g2_decap_4
X_2629_ _0958_ _0977_ _1018_ VPWR VGND sg13g2_nor2_2
XFILLER_43_1018 VPWR VGND sg13g2_decap_8
XFILLER_0_749 VPWR VGND sg13g2_decap_8
XFILLER_46_35 VPWR VGND sg13g2_decap_4
XFILLER_29_967 VPWR VGND sg13g2_decap_8
XFILLER_44_937 VPWR VGND sg13g2_decap_8
XFILLER_43_403 VPWR VGND sg13g2_decap_8
XFILLER_15_105 VPWR VGND sg13g2_fill_2
XFILLER_16_639 VPWR VGND sg13g2_decap_8
XFILLER_43_458 VPWR VGND sg13g2_fill_2
XFILLER_12_801 VPWR VGND sg13g2_decap_8
XFILLER_24_694 VPWR VGND sg13g2_decap_8
X_2803__70 VPWR VGND net70 sg13g2_tiehi
XFILLER_8_838 VPWR VGND sg13g2_decap_8
XFILLER_12_878 VPWR VGND sg13g2_decap_8
XFILLER_3_554 VPWR VGND sg13g2_decap_8
XFILLER_16_8 VPWR VGND sg13g2_fill_1
Xfanout390 net395 net390 VPWR VGND sg13g2_buf_8
XFILLER_47_742 VPWR VGND sg13g2_decap_8
XFILLER_34_414 VPWR VGND sg13g2_decap_8
XFILLER_35_948 VPWR VGND sg13g2_decap_8
XFILLER_15_650 VPWR VGND sg13g2_decap_8
XFILLER_34_469 VPWR VGND sg13g2_decap_8
X_1931_ _0455_ _0441_ _0456_ VPWR VGND sg13g2_nor2b_1
XFILLER_14_160 VPWR VGND sg13g2_decap_4
X_1862_ _0389_ falutop.div_inst.rem\[1\] _0388_ VPWR VGND sg13g2_xnor2_1
X_1793_ net340 net348 _0321_ VPWR VGND sg13g2_nor2b_1
XFILLER_7_871 VPWR VGND sg13g2_decap_8
X_2414_ _0851_ VPWR _0856_ VGND _0824_ _0825_ sg13g2_o21ai_1
XFILLER_35_0 VPWR VGND sg13g2_decap_8
X_2345_ _0798_ VPWR _0011_ VGND _0731_ _0801_ sg13g2_o21ai_1
X_2276_ _0706_ net376 _0743_ VPWR VGND sg13g2_nor2_1
XFILLER_38_742 VPWR VGND sg13g2_fill_2
XFILLER_38_786 VPWR VGND sg13g2_decap_8
XFILLER_37_274 VPWR VGND sg13g2_decap_8
XFILLER_25_425 VPWR VGND sg13g2_fill_2
XFILLER_26_937 VPWR VGND sg13g2_decap_8
XFILLER_41_907 VPWR VGND sg13g2_decap_8
XFILLER_16_27 VPWR VGND sg13g2_fill_2
XFILLER_16_49 VPWR VGND sg13g2_decap_4
XFILLER_25_436 VPWR VGND sg13g2_decap_8
XFILLER_34_981 VPWR VGND sg13g2_decap_8
XFILLER_40_428 VPWR VGND sg13g2_decap_8
XFILLER_21_653 VPWR VGND sg13g2_decap_4
X_2797__80 VPWR VGND net80 sg13g2_tiehi
XFILLER_5_819 VPWR VGND sg13g2_decap_8
XFILLER_10_1028 VPWR VGND sg13g2_fill_1
XFILLER_0_546 VPWR VGND sg13g2_decap_8
X_2870__114 VPWR VGND net114 sg13g2_tiehi
XFILLER_28_274 VPWR VGND sg13g2_decap_8
XFILLER_44_756 VPWR VGND sg13g2_decap_8
XFILLER_43_233 VPWR VGND sg13g2_decap_8
XFILLER_17_959 VPWR VGND sg13g2_decap_8
XFILLER_43_266 VPWR VGND sg13g2_decap_8
XFILLER_43_299 VPWR VGND sg13g2_decap_8
XFILLER_40_940 VPWR VGND sg13g2_decap_8
XFILLER_12_653 VPWR VGND sg13g2_fill_2
XFILLER_24_491 VPWR VGND sg13g2_decap_8
XFILLER_8_635 VPWR VGND sg13g2_decap_8
XFILLER_7_112 VPWR VGND sg13g2_decap_8
XFILLER_11_185 VPWR VGND sg13g2_decap_4
XFILLER_7_189 VPWR VGND sg13g2_fill_2
XFILLER_7_178 VPWR VGND sg13g2_fill_2
XFILLER_7_167 VPWR VGND sg13g2_decap_8
XFILLER_4_852 VPWR VGND sg13g2_decap_8
XFILLER_3_351 VPWR VGND sg13g2_decap_8
X_2130_ VGND VPWR net292 _0627_ _0117_ _0625_ sg13g2_a21oi_1
X_2061_ VGND VPWR _0577_ _0581_ _0093_ _0582_ sg13g2_a21oi_1
XFILLER_35_745 VPWR VGND sg13g2_decap_8
XFILLER_35_756 VPWR VGND sg13g2_fill_1
XFILLER_23_918 VPWR VGND sg13g2_decap_8
XFILLER_34_277 VPWR VGND sg13g2_decap_8
X_1914_ _0439_ _0350_ _0438_ VPWR VGND sg13g2_nand2_1
XFILLER_31_962 VPWR VGND sg13g2_decap_8
X_2894_ net167 VGND VPWR net183 falutop.div_inst.a\[2\] clknet_5_20__leaf_clk sg13g2_dfrbpq_1
X_1845_ _0372_ _0347_ _0371_ VPWR VGND sg13g2_nand2b_1
X_1776_ _0265_ VPWR _0304_ VGND _0188_ _0266_ sg13g2_o21ai_1
X_2893__169 VPWR VGND net169 sg13g2_tiehi
X_2328_ _0788_ net238 net270 VPWR VGND sg13g2_nand2_1
X_2259_ VPWR _0727_ net2 VGND sg13g2_inv_1
XFILLER_26_701 VPWR VGND sg13g2_decap_8
XFILLER_27_59 VPWR VGND sg13g2_decap_8
XFILLER_26_734 VPWR VGND sg13g2_decap_8
XFILLER_43_14 VPWR VGND sg13g2_decap_8
XFILLER_26_767 VPWR VGND sg13g2_decap_8
XFILLER_22_962 VPWR VGND sg13g2_decap_8
XFILLER_5_616 VPWR VGND sg13g2_decap_8
XFILLER_4_137 VPWR VGND sg13g2_decap_8
XFILLER_1_833 VPWR VGND sg13g2_decap_8
XFILLER_49_804 VPWR VGND sg13g2_decap_8
XFILLER_0_343 VPWR VGND sg13g2_decap_8
XFILLER_1_1015 VPWR VGND sg13g2_decap_8
XFILLER_29_594 VPWR VGND sg13g2_decap_8
XFILLER_44_553 VPWR VGND sg13g2_fill_1
XFILLER_17_70 VPWR VGND sg13g2_decap_8
XFILLER_17_767 VPWR VGND sg13g2_decap_4
XFILLER_16_277 VPWR VGND sg13g2_fill_2
XFILLER_9_922 VPWR VGND sg13g2_decap_8
XFILLER_9_999 VPWR VGND sg13g2_decap_8
X_1630_ VPWR VGND _0916_ _0159_ _1016_ _0919_ _0161_ _1012_ sg13g2_a221oi_1
X_1561_ _0935_ _1000_ _1011_ _1262_ VPWR VGND sg13g2_nor3_1
X_1492_ _1194_ net336 net325 VPWR VGND sg13g2_nand2_1
X_2113_ net372 net315 net285 _0112_ VPWR VGND sg13g2_mux2_1
X_2044_ _0566_ _0558_ _0565_ VPWR VGND sg13g2_nand2b_1
XFILLER_35_542 VPWR VGND sg13g2_fill_1
Xclkbuf_5_1__f_clk clknet_4_0_0_clk clknet_5_1__leaf_clk VPWR VGND sg13g2_buf_8
XFILLER_22_236 VPWR VGND sg13g2_decap_8
XFILLER_30_291 VPWR VGND sg13g2_fill_1
X_2877_ net89 VGND VPWR net498 falutop.alu_data_in\[1\] clknet_5_12__leaf_clk sg13g2_dfrbpq_2
X_1828_ _0355_ _0307_ _0354_ VPWR VGND sg13g2_xnor2_1
X_1759_ _0288_ _0258_ _0286_ VPWR VGND sg13g2_xnor2_1
XFILLER_39_870 VPWR VGND sg13g2_decap_8
XFILLER_18_509 VPWR VGND sg13g2_decap_4
XFILLER_26_542 VPWR VGND sg13g2_decap_4
XFILLER_41_512 VPWR VGND sg13g2_decap_8
XFILLER_16_1001 VPWR VGND sg13g2_decap_8
XFILLER_10_921 VPWR VGND sg13g2_decap_8
XFILLER_21_291 VPWR VGND sg13g2_decap_8
XFILLER_6_958 VPWR VGND sg13g2_decap_8
XFILLER_10_998 VPWR VGND sg13g2_decap_8
XFILLER_1_630 VPWR VGND sg13g2_decap_8
XFILLER_49_601 VPWR VGND sg13g2_decap_8
XFILLER_0_140 VPWR VGND sg13g2_decap_8
XFILLER_23_1016 VPWR VGND sg13g2_decap_8
XFILLER_23_1027 VPWR VGND sg13g2_fill_2
XFILLER_49_678 VPWR VGND sg13g2_decap_8
XFILLER_37_829 VPWR VGND sg13g2_decap_8
XFILLER_45_840 VPWR VGND sg13g2_decap_8
XFILLER_32_512 VPWR VGND sg13g2_decap_8
XFILLER_32_523 VPWR VGND sg13g2_fill_2
XFILLER_44_90 VPWR VGND sg13g2_fill_1
X_2800_ net76 VGND VPWR _0021_ falutop.i2c_inst.state\[1\] clknet_5_15__leaf_clk sg13g2_dfrbpq_2
X_2731_ _1118_ _1111_ _1117_ VPWR VGND sg13g2_nand2_1
XFILLER_8_273 VPWR VGND sg13g2_decap_8
XFILLER_9_796 VPWR VGND sg13g2_decap_8
X_2662_ _1050_ _0946_ _0948_ _1049_ VPWR VGND sg13g2_and3_1
X_2593_ VGND VPWR _0982_ net315 net319 sg13g2_or2_1
X_1613_ _1313_ _1306_ _1312_ VPWR VGND sg13g2_xnor2_1
XFILLER_5_980 VPWR VGND sg13g2_decap_8
X_1544_ _1245_ net339 net358 VPWR VGND sg13g2_nand2_1
Xclkbuf_4_7_0_clk clknet_0_clk clknet_4_7_0_clk VPWR VGND sg13g2_buf_8
X_1475_ _0968_ _1006_ _1177_ VPWR VGND sg13g2_nor2b_1
XFILLER_39_122 VPWR VGND sg13g2_decap_4
XFILLER_39_199 VPWR VGND sg13g2_decap_8
XFILLER_27_339 VPWR VGND sg13g2_decap_8
X_2027_ _0339_ VPWR _0550_ VGND _0548_ _0549_ sg13g2_o21ai_1
XFILLER_23_512 VPWR VGND sg13g2_fill_1
XFILLER_35_383 VPWR VGND sg13g2_fill_1
XFILLER_23_534 VPWR VGND sg13g2_decap_8
XFILLER_23_589 VPWR VGND sg13g2_decap_8
XFILLER_40_59 VPWR VGND sg13g2_fill_2
XFILLER_3_939 VPWR VGND sg13g2_decap_8
XFILLER_2_438 VPWR VGND sg13g2_decap_8
XFILLER_49_35 VPWR VGND sg13g2_decap_8
XFILLER_46_1027 VPWR VGND sg13g2_fill_2
XFILLER_46_1016 VPWR VGND sg13g2_decap_8
XFILLER_46_659 VPWR VGND sg13g2_decap_8
XFILLER_46_637 VPWR VGND sg13g2_decap_4
XFILLER_18_339 VPWR VGND sg13g2_fill_1
XFILLER_33_309 VPWR VGND sg13g2_decap_8
XFILLER_14_534 VPWR VGND sg13g2_fill_1
XFILLER_42_898 VPWR VGND sg13g2_decap_8
XFILLER_41_386 VPWR VGND sg13g2_fill_1
XFILLER_10_795 VPWR VGND sg13g2_decap_8
XFILLER_6_755 VPWR VGND sg13g2_decap_8
XFILLER_5_265 VPWR VGND sg13g2_fill_2
XFILLER_49_475 VPWR VGND sg13g2_decap_8
XFILLER_37_659 VPWR VGND sg13g2_decap_8
XFILLER_36_158 VPWR VGND sg13g2_fill_1
XFILLER_45_670 VPWR VGND sg13g2_decap_8
XFILLER_33_832 VPWR VGND sg13g2_decap_8
XFILLER_32_353 VPWR VGND sg13g2_decap_4
XFILLER_32_375 VPWR VGND sg13g2_decap_8
XFILLER_20_559 VPWR VGND sg13g2_decap_8
X_2714_ _1100_ _1101_ _0080_ VPWR VGND sg13g2_nor2_1
XFILLER_10_18 VPWR VGND sg13g2_decap_8
X_2645_ _1034_ _0716_ net338 VPWR VGND sg13g2_nand2_1
X_2576_ _0965_ net366 net342 VPWR VGND sg13g2_nand2b_1
X_1527_ _1228_ _1214_ _1227_ VPWR VGND sg13g2_xnor2_1
XFILLER_19_16 VPWR VGND sg13g2_decap_8
XFILLER_28_604 VPWR VGND sg13g2_decap_8
XFILLER_27_158 VPWR VGND sg13g2_decap_8
XFILLER_36_681 VPWR VGND sg13g2_decap_4
XFILLER_35_191 VPWR VGND sg13g2_decap_8
XFILLER_36_692 VPWR VGND sg13g2_decap_8
XFILLER_3_736 VPWR VGND sg13g2_decap_8
XFILLER_4_4 VPWR VGND sg13g2_decap_8
XFILLER_2_235 VPWR VGND sg13g2_decap_8
XFILLER_47_924 VPWR VGND sg13g2_decap_8
XFILLER_46_423 VPWR VGND sg13g2_decap_8
XFILLER_18_114 VPWR VGND sg13g2_fill_1
XFILLER_20_1019 VPWR VGND sg13g2_decap_8
XFILLER_18_158 VPWR VGND sg13g2_decap_8
XFILLER_34_607 VPWR VGND sg13g2_fill_1
XFILLER_27_681 VPWR VGND sg13g2_decap_8
XFILLER_27_692 VPWR VGND sg13g2_fill_1
XFILLER_15_887 VPWR VGND sg13g2_decap_8
XFILLER_30_813 VPWR VGND sg13g2_fill_2
XFILLER_6_552 VPWR VGND sg13g2_decap_8
X_2430_ net252 falutop.data_in\[4\] net311 _0032_ VPWR VGND sg13g2_mux2_1
X_2361_ _0814_ _0765_ _0784_ VPWR VGND sg13g2_xnor2_1
X_2292_ _0702_ net376 _0755_ VPWR VGND sg13g2_nor2_1
XFILLER_49_250 VPWR VGND sg13g2_decap_8
XFILLER_38_924 VPWR VGND sg13g2_decap_8
XFILLER_49_283 VPWR VGND sg13g2_decap_8
XFILLER_2_74 VPWR VGND sg13g2_decap_8
XFILLER_18_670 VPWR VGND sg13g2_decap_8
XFILLER_24_106 VPWR VGND sg13g2_decap_8
XFILLER_36_1004 VPWR VGND sg13g2_decap_8
XFILLER_21_846 VPWR VGND sg13g2_fill_2
XFILLER_32_183 VPWR VGND sg13g2_fill_1
X_2628_ falutop.alu_inst.op\[2\] net369 _0977_ _1017_ VPWR VGND sg13g2_nor3_2
XFILLER_0_728 VPWR VGND sg13g2_decap_8
X_2559_ _0948_ _0937_ _0947_ VPWR VGND sg13g2_nand2_1
XFILLER_46_14 VPWR VGND sg13g2_decap_8
XFILLER_29_946 VPWR VGND sg13g2_decap_8
XFILLER_46_58 VPWR VGND sg13g2_decap_4
XFILLER_44_916 VPWR VGND sg13g2_decap_8
XFILLER_16_607 VPWR VGND sg13g2_decap_8
XFILLER_24_651 VPWR VGND sg13g2_decap_4
XFILLER_23_183 VPWR VGND sg13g2_decap_8
XFILLER_8_817 VPWR VGND sg13g2_decap_8
XFILLER_12_857 VPWR VGND sg13g2_decap_8
XFILLER_23_194 VPWR VGND sg13g2_fill_2
XFILLER_11_367 VPWR VGND sg13g2_decap_4
XFILLER_11_389 VPWR VGND sg13g2_decap_4
XFILLER_3_533 VPWR VGND sg13g2_decap_8
XFILLER_47_721 VPWR VGND sg13g2_decap_8
Xfanout391 net394 net391 VPWR VGND sg13g2_buf_8
XFILLER_4_1013 VPWR VGND sg13g2_decap_8
Xfanout380 net438 net380 VPWR VGND sg13g2_buf_8
XFILLER_47_798 VPWR VGND sg13g2_decap_8
XFILLER_46_253 VPWR VGND sg13g2_decap_4
XFILLER_35_927 VPWR VGND sg13g2_decap_8
XFILLER_21_109 VPWR VGND sg13g2_decap_8
X_1930_ _0455_ _0445_ _0454_ VPWR VGND sg13g2_xnor2_1
XFILLER_15_684 VPWR VGND sg13g2_decap_8
X_1861_ _0388_ net372 falutop.div_inst.rem\[0\] VPWR VGND sg13g2_nand2_1
XFILLER_30_665 VPWR VGND sg13g2_decap_8
XFILLER_7_850 VPWR VGND sg13g2_decap_8
X_1792_ _0320_ net325 net359 VPWR VGND sg13g2_nand2_1
X_2413_ net387 net1 _0710_ _0855_ VPWR VGND _0727_ sg13g2_nand4_1
XFILLER_42_2 VPWR VGND sg13g2_fill_1
X_2344_ _0800_ VPWR _0801_ VGND net236 net269 sg13g2_o21ai_1
XFILLER_38_732 VPWR VGND sg13g2_fill_1
X_2275_ VGND VPWR net275 net213 _0000_ _0742_ sg13g2_a21oi_1
XFILLER_38_765 VPWR VGND sg13g2_fill_1
XFILLER_37_253 VPWR VGND sg13g2_decap_8
XFILLER_26_916 VPWR VGND sg13g2_decap_8
XFILLER_37_297 VPWR VGND sg13g2_fill_1
XFILLER_40_407 VPWR VGND sg13g2_decap_8
XFILLER_34_960 VPWR VGND sg13g2_decap_8
XFILLER_33_492 VPWR VGND sg13g2_decap_8
XFILLER_21_676 VPWR VGND sg13g2_decap_8
XFILLER_21_698 VPWR VGND sg13g2_decap_4
XFILLER_20_197 VPWR VGND sg13g2_decap_4
XFILLER_0_525 VPWR VGND sg13g2_decap_8
X_2911__123 VPWR VGND net123 sg13g2_tiehi
XFILLER_29_754 VPWR VGND sg13g2_fill_1
XFILLER_44_702 VPWR VGND sg13g2_decap_4
XFILLER_17_938 VPWR VGND sg13g2_decap_8
XFILLER_29_787 VPWR VGND sg13g2_decap_8
XFILLER_43_212 VPWR VGND sg13g2_decap_8
XFILLER_44_779 VPWR VGND sg13g2_decap_8
XFILLER_16_459 VPWR VGND sg13g2_decap_8
XFILLER_25_993 VPWR VGND sg13g2_decap_8
XFILLER_40_996 VPWR VGND sg13g2_decap_8
XFILLER_8_614 VPWR VGND sg13g2_decap_8
XFILLER_12_698 VPWR VGND sg13g2_fill_2
XFILLER_7_146 VPWR VGND sg13g2_decap_8
XFILLER_11_197 VPWR VGND sg13g2_fill_1
XFILLER_4_831 VPWR VGND sg13g2_decap_8
XFILLER_3_330 VPWR VGND sg13g2_decap_8
XFILLER_26_1014 VPWR VGND sg13g2_decap_8
X_2060_ net391 VPWR _0582_ VGND net477 net294 sg13g2_o21ai_1
XFILLER_47_562 VPWR VGND sg13g2_fill_1
XFILLER_35_724 VPWR VGND sg13g2_decap_4
XFILLER_19_275 VPWR VGND sg13g2_decap_8
XFILLER_34_234 VPWR VGND sg13g2_decap_4
XFILLER_34_256 VPWR VGND sg13g2_decap_8
XFILLER_31_941 VPWR VGND sg13g2_decap_8
X_1913_ _0400_ VPWR _0438_ VGND _0916_ _0398_ sg13g2_o21ai_1
X_2893_ net169 VGND VPWR net179 falutop.div_inst.a\[1\] clknet_5_20__leaf_clk sg13g2_dfrbpq_1
XFILLER_30_451 VPWR VGND sg13g2_decap_8
X_1844_ _0371_ _0355_ _0370_ VPWR VGND sg13g2_xnor2_1
XFILLER_30_484 VPWR VGND sg13g2_decap_4
X_1775_ VGND VPWR _0270_ _0284_ _0303_ _0283_ sg13g2_a21oi_1
X_2794__84 VPWR VGND net84 sg13g2_tiehi
X_2327_ _0786_ VPWR _0787_ VGND falutop.div_inst.b1\[7\] _0715_ sg13g2_o21ai_1
X_2258_ VPWR _0726_ net363 VGND sg13g2_inv_1
XFILLER_38_562 VPWR VGND sg13g2_fill_2
X_2189_ _0660_ _0665_ _0670_ VPWR VGND sg13g2_nor2_1
XFILLER_41_716 VPWR VGND sg13g2_decap_8
XFILLER_13_407 VPWR VGND sg13g2_decap_8
XFILLER_22_941 VPWR VGND sg13g2_decap_8
XFILLER_21_495 VPWR VGND sg13g2_decap_8
XFILLER_49_1014 VPWR VGND sg13g2_decap_8
XFILLER_4_116 VPWR VGND sg13g2_decap_8
XFILLER_1_812 VPWR VGND sg13g2_decap_8
XFILLER_0_322 VPWR VGND sg13g2_decap_8
XFILLER_1_889 VPWR VGND sg13g2_decap_8
XFILLER_48_337 VPWR VGND sg13g2_fill_1
XFILLER_0_399 VPWR VGND sg13g2_decap_8
XFILLER_29_573 VPWR VGND sg13g2_decap_8
XFILLER_44_510 VPWR VGND sg13g2_decap_4
XFILLER_16_201 VPWR VGND sg13g2_fill_2
XFILLER_17_746 VPWR VGND sg13g2_decap_8
XFILLER_9_901 VPWR VGND sg13g2_decap_8
XFILLER_12_473 VPWR VGND sg13g2_fill_2
XFILLER_13_985 VPWR VGND sg13g2_decap_8
XFILLER_9_978 VPWR VGND sg13g2_decap_8
X_1560_ _1008_ _1014_ _0936_ _1261_ VPWR VGND sg13g2_mux2_1
X_2918__129 VPWR VGND net129 sg13g2_tiehi
X_1491_ _1118_ VPWR _1193_ VGND _1110_ _1119_ sg13g2_o21ai_1
XFILLER_3_193 VPWR VGND sg13g2_decap_8
X_2112_ VGND VPWR _0720_ net284 _0111_ _0615_ sg13g2_a21oi_1
XFILLER_48_882 VPWR VGND sg13g2_decap_8
X_2043_ _0565_ _0523_ _0564_ VPWR VGND sg13g2_xnor2_1
XFILLER_23_727 VPWR VGND sg13g2_decap_8
XFILLER_31_793 VPWR VGND sg13g2_decap_8
X_2876_ net91 VGND VPWR _0097_ falutop.alu_data_in\[0\] clknet_5_12__leaf_clk sg13g2_dfrbpq_2
X_1827_ _0351_ _0348_ _0354_ VPWR VGND sg13g2_xor2_1
X_1758_ _0287_ _0258_ _0286_ VPWR VGND sg13g2_nand2_1
XFILLER_1_119 VPWR VGND sg13g2_decap_8
X_1689_ VGND VPWR _0720_ net273 _0219_ _0218_ sg13g2_a21oi_1
XFILLER_38_37 VPWR VGND sg13g2_decap_8
XFILLER_26_521 VPWR VGND sg13g2_decap_8
XFILLER_14_749 VPWR VGND sg13g2_decap_8
XFILLER_10_900 VPWR VGND sg13g2_decap_8
XFILLER_22_793 VPWR VGND sg13g2_decap_8
XFILLER_6_937 VPWR VGND sg13g2_decap_8
XFILLER_10_977 VPWR VGND sg13g2_decap_8
XFILLER_5_469 VPWR VGND sg13g2_decap_8
XFILLER_1_686 VPWR VGND sg13g2_decap_8
XFILLER_49_657 VPWR VGND sg13g2_decap_8
XFILLER_0_196 VPWR VGND sg13g2_decap_8
XFILLER_48_167 VPWR VGND sg13g2_fill_2
XFILLER_37_819 VPWR VGND sg13g2_decap_4
XFILLER_29_381 VPWR VGND sg13g2_decap_4
XFILLER_17_532 VPWR VGND sg13g2_decap_8
XFILLER_45_896 VPWR VGND sg13g2_decap_8
XFILLER_20_719 VPWR VGND sg13g2_decap_4
X_2730_ _1116_ _1112_ _1117_ VPWR VGND sg13g2_xor2_1
XFILLER_13_782 VPWR VGND sg13g2_fill_1
XFILLER_9_775 VPWR VGND sg13g2_decap_8
X_2661_ VGND VPWR _0929_ _0951_ _1049_ _0950_ sg13g2_a21oi_1
X_1612_ _1310_ _1309_ _1312_ VPWR VGND sg13g2_xor2_1
X_2592_ net271 _0716_ _0980_ _0981_ VPWR VGND sg13g2_a21o_1
X_1543_ _1242_ _1243_ _1244_ VPWR VGND sg13g2_nor2_1
XFILLER_5_85 VPWR VGND sg13g2_fill_2
XFILLER_5_74 VPWR VGND sg13g2_decap_8
X_1474_ _0964_ _0967_ _0925_ _1176_ VPWR VGND sg13g2_nand3_1
XFILLER_48_690 VPWR VGND sg13g2_fill_2
X_2026_ net282 VPWR _0549_ VGND net324 net272 sg13g2_o21ai_1
XFILLER_36_841 VPWR VGND sg13g2_fill_2
XFILLER_39_1024 VPWR VGND sg13g2_decap_4
XFILLER_35_351 VPWR VGND sg13g2_decap_8
XFILLER_36_885 VPWR VGND sg13g2_decap_8
XFILLER_10_218 VPWR VGND sg13g2_fill_1
X_2859_ net136 VGND VPWR net470 falutop.i2c_inst.result\[1\] clknet_5_22__leaf_clk
+ sg13g2_dfrbpq_1
XFILLER_3_918 VPWR VGND sg13g2_decap_8
XFILLER_2_417 VPWR VGND sg13g2_decap_8
XFILLER_49_14 VPWR VGND sg13g2_decap_8
XFILLER_46_616 VPWR VGND sg13g2_decap_8
XFILLER_42_822 VPWR VGND sg13g2_fill_1
XFILLER_14_502 VPWR VGND sg13g2_decap_8
XFILLER_14_513 VPWR VGND sg13g2_fill_2
XFILLER_26_362 VPWR VGND sg13g2_decap_8
XFILLER_27_896 VPWR VGND sg13g2_fill_2
XFILLER_41_332 VPWR VGND sg13g2_decap_4
XFILLER_14_557 VPWR VGND sg13g2_fill_2
XFILLER_26_384 VPWR VGND sg13g2_fill_1
XFILLER_42_877 VPWR VGND sg13g2_decap_8
XFILLER_6_734 VPWR VGND sg13g2_decap_8
XFILLER_10_774 VPWR VGND sg13g2_decap_8
XFILLER_5_277 VPWR VGND sg13g2_fill_1
XFILLER_30_71 VPWR VGND sg13g2_fill_1
XFILLER_2_984 VPWR VGND sg13g2_decap_8
XFILLER_7_1011 VPWR VGND sg13g2_decap_8
XFILLER_1_483 VPWR VGND sg13g2_decap_8
XFILLER_49_454 VPWR VGND sg13g2_decap_8
XFILLER_39_80 VPWR VGND sg13g2_decap_8
XFILLER_36_148 VPWR VGND sg13g2_fill_1
XFILLER_17_351 VPWR VGND sg13g2_fill_2
XFILLER_18_874 VPWR VGND sg13g2_fill_1
XFILLER_32_321 VPWR VGND sg13g2_decap_8
XFILLER_20_527 VPWR VGND sg13g2_fill_2
XFILLER_9_583 VPWR VGND sg13g2_decap_4
X_2713_ net390 VPWR _1101_ VGND net469 net293 sg13g2_o21ai_1
X_2779__125 VPWR VGND net125 sg13g2_tiehi
X_2644_ _1030_ _1032_ _1033_ VPWR VGND sg13g2_nor2b_1
X_2575_ _0964_ _0718_ net363 VPWR VGND sg13g2_nand2_1
X_1526_ _1224_ _1215_ _1227_ VPWR VGND sg13g2_xor2_1
XFILLER_27_126 VPWR VGND sg13g2_decap_4
XFILLER_24_811 VPWR VGND sg13g2_decap_8
X_2009_ _0532_ _0490_ _0530_ VPWR VGND sg13g2_xnor2_1
XFILLER_24_844 VPWR VGND sg13g2_decap_8
XFILLER_24_866 VPWR VGND sg13g2_decap_8
XFILLER_24_877 VPWR VGND sg13g2_fill_2
XFILLER_13_1027 VPWR VGND sg13g2_fill_2
XFILLER_3_715 VPWR VGND sg13g2_decap_8
XFILLER_2_214 VPWR VGND sg13g2_decap_8
XFILLER_47_903 VPWR VGND sg13g2_decap_8
XFILLER_46_402 VPWR VGND sg13g2_decap_8
XFILLER_19_649 VPWR VGND sg13g2_decap_8
XFILLER_18_148 VPWR VGND sg13g2_fill_1
XFILLER_42_630 VPWR VGND sg13g2_decap_8
XFILLER_14_310 VPWR VGND sg13g2_decap_8
XFILLER_26_181 VPWR VGND sg13g2_decap_8
XFILLER_33_129 VPWR VGND sg13g2_fill_1
XFILLER_14_354 VPWR VGND sg13g2_decap_4
XFILLER_15_866 VPWR VGND sg13g2_decap_8
XFILLER_42_685 VPWR VGND sg13g2_fill_1
XFILLER_41_184 VPWR VGND sg13g2_decap_8
Xclkbuf_4_6_0_clk clknet_0_clk clknet_4_6_0_clk VPWR VGND sg13g2_buf_8
XFILLER_41_81 VPWR VGND sg13g2_decap_8
XFILLER_41_70 VPWR VGND sg13g2_fill_2
XFILLER_6_531 VPWR VGND sg13g2_decap_8
XFILLER_29_1023 VPWR VGND sg13g2_decap_4
X_2360_ _0810_ VPWR _0014_ VGND _0731_ _0813_ sg13g2_o21ai_1
X_2291_ VGND VPWR net275 _0753_ _0004_ _0754_ sg13g2_a21oi_1
XFILLER_2_781 VPWR VGND sg13g2_decap_8
XFILLER_38_903 VPWR VGND sg13g2_decap_8
XFILLER_1_280 VPWR VGND sg13g2_decap_8
XFILLER_2_53 VPWR VGND sg13g2_decap_8
XFILLER_49_262 VPWR VGND sg13g2_decap_8
XFILLER_37_413 VPWR VGND sg13g2_decap_8
XFILLER_37_479 VPWR VGND sg13g2_fill_2
XFILLER_21_814 VPWR VGND sg13g2_fill_2
XFILLER_33_663 VPWR VGND sg13g2_decap_8
XFILLER_33_674 VPWR VGND sg13g2_fill_1
XFILLER_21_825 VPWR VGND sg13g2_decap_8
XFILLER_32_173 VPWR VGND sg13g2_fill_1
XFILLER_20_335 VPWR VGND sg13g2_fill_2
XFILLER_20_346 VPWR VGND sg13g2_decap_4
X_2627_ _1000_ _1011_ _1016_ VPWR VGND sg13g2_nor2_2
XFILLER_0_707 VPWR VGND sg13g2_decap_8
X_2558_ _0945_ _0946_ _0947_ VPWR VGND sg13g2_nor2b_2
X_1509_ _1211_ net235 _1210_ VPWR VGND sg13g2_xnor2_1
X_2489_ net485 net425 _0736_ _0059_ VPWR VGND sg13g2_mux2_1
XFILLER_29_925 VPWR VGND sg13g2_decap_8
XFILLER_43_438 VPWR VGND sg13g2_decap_8
XFILLER_37_991 VPWR VGND sg13g2_decap_8
XFILLER_24_630 VPWR VGND sg13g2_decap_8
XFILLER_12_836 VPWR VGND sg13g2_decap_8
XFILLER_23_151 VPWR VGND sg13g2_fill_2
XFILLER_23_162 VPWR VGND sg13g2_decap_8
XFILLER_11_346 VPWR VGND sg13g2_decap_8
XFILLER_7_328 VPWR VGND sg13g2_fill_1
XFILLER_3_512 VPWR VGND sg13g2_decap_8
XFILLER_11_62 VPWR VGND sg13g2_fill_2
XFILLER_3_589 VPWR VGND sg13g2_decap_8
XFILLER_47_700 VPWR VGND sg13g2_decap_4
Xfanout392 net393 net392 VPWR VGND sg13g2_buf_8
Xfanout370 net371 net370 VPWR VGND sg13g2_buf_8
XFILLER_19_402 VPWR VGND sg13g2_decap_8
Xfanout381 net441 net381 VPWR VGND sg13g2_buf_8
XFILLER_46_232 VPWR VGND sg13g2_decap_8
XFILLER_35_906 VPWR VGND sg13g2_decap_8
XFILLER_47_777 VPWR VGND sg13g2_decap_8
XFILLER_46_298 VPWR VGND sg13g2_decap_8
XFILLER_36_92 VPWR VGND sg13g2_decap_8
XFILLER_43_983 VPWR VGND sg13g2_decap_8
XFILLER_30_600 VPWR VGND sg13g2_decap_8
XFILLER_30_611 VPWR VGND sg13g2_fill_2
X_1860_ _0384_ _0386_ _0339_ _0387_ VPWR VGND sg13g2_nand3_1
XFILLER_30_677 VPWR VGND sg13g2_decap_8
X_1791_ VGND VPWR net345 _0277_ _0319_ _0724_ sg13g2_a21oi_1
X_2412_ _0714_ _0854_ _0025_ VPWR VGND sg13g2_nor2_1
X_2343_ _0800_ net270 _0799_ VPWR VGND sg13g2_nand2_1
X_2274_ net208 net275 _0742_ VPWR VGND sg13g2_nor2_1
XFILLER_37_232 VPWR VGND sg13g2_decap_8
XFILLER_25_416 VPWR VGND sg13g2_decap_4
XFILLER_16_29 VPWR VGND sg13g2_fill_1
XFILLER_19_991 VPWR VGND sg13g2_decap_8
XFILLER_20_154 VPWR VGND sg13g2_decap_8
X_1989_ _0339_ VPWR _0513_ VGND _0511_ _0512_ sg13g2_o21ai_1
XFILLER_10_1019 VPWR VGND sg13g2_decap_8
XFILLER_0_504 VPWR VGND sg13g2_decap_8
XFILLER_29_733 VPWR VGND sg13g2_decap_8
XFILLER_17_917 VPWR VGND sg13g2_decap_8
XFILLER_29_766 VPWR VGND sg13g2_decap_8
XFILLER_16_438 VPWR VGND sg13g2_decap_8
XFILLER_32_909 VPWR VGND sg13g2_decap_8
XFILLER_25_972 VPWR VGND sg13g2_decap_8
XFILLER_40_975 VPWR VGND sg13g2_decap_8
XFILLER_12_677 VPWR VGND sg13g2_decap_8
XFILLER_7_125 VPWR VGND sg13g2_decap_4
XFILLER_22_61 VPWR VGND sg13g2_decap_8
XFILLER_4_810 VPWR VGND sg13g2_decap_8
XFILLER_22_72 VPWR VGND sg13g2_fill_2
XFILLER_22_83 VPWR VGND sg13g2_decap_8
XFILLER_4_887 VPWR VGND sg13g2_decap_8
XFILLER_3_386 VPWR VGND sg13g2_decap_8
XFILLER_47_585 VPWR VGND sg13g2_decap_4
XFILLER_34_213 VPWR VGND sg13g2_decap_8
XFILLER_35_736 VPWR VGND sg13g2_decap_4
XFILLER_35_769 VPWR VGND sg13g2_decap_8
XFILLER_16_994 VPWR VGND sg13g2_decap_8
XFILLER_31_920 VPWR VGND sg13g2_decap_8
X_1912_ VGND VPWR _0396_ _0414_ _0437_ _0413_ sg13g2_a21oi_1
XFILLER_33_1008 VPWR VGND sg13g2_decap_8
X_2892_ net33 VGND VPWR _0113_ falutop.div_inst.a\[0\] clknet_5_16__leaf_clk sg13g2_dfrbpq_1
XFILLER_30_441 VPWR VGND sg13g2_decap_4
XFILLER_31_997 VPWR VGND sg13g2_decap_8
X_1843_ _0370_ _0356_ _0368_ VPWR VGND sg13g2_xnor2_1
XFILLER_8_74 VPWR VGND sg13g2_decap_8
XFILLER_8_96 VPWR VGND sg13g2_decap_8
X_1774_ _0268_ VPWR _0302_ VGND _0189_ _0269_ sg13g2_o21ai_1
XFILLER_6_191 VPWR VGND sg13g2_fill_2
XFILLER_40_0 VPWR VGND sg13g2_decap_8
X_2326_ net400 _0785_ _0786_ VPWR VGND sg13g2_nor2_1
XFILLER_38_530 VPWR VGND sg13g2_decap_4
X_2257_ _0725_ net349 VPWR VGND sg13g2_inv_2
XFILLER_27_28 VPWR VGND sg13g2_decap_8
XFILLER_27_39 VPWR VGND sg13g2_fill_2
X_2188_ VGND VPWR net382 _0668_ _0133_ _0669_ sg13g2_a21oi_1
XFILLER_22_920 VPWR VGND sg13g2_decap_8
XFILLER_43_49 VPWR VGND sg13g2_decap_8
XFILLER_22_997 VPWR VGND sg13g2_decap_8
XFILLER_0_301 VPWR VGND sg13g2_decap_8
XFILLER_1_868 VPWR VGND sg13g2_decap_8
XFILLER_49_839 VPWR VGND sg13g2_decap_8
XFILLER_0_378 VPWR VGND sg13g2_decap_8
Xclkbuf_5_26__f_clk clknet_4_13_0_clk clknet_5_26__leaf_clk VPWR VGND sg13g2_buf_8
XFILLER_17_703 VPWR VGND sg13g2_fill_1
XFILLER_44_500 VPWR VGND sg13g2_decap_4
XFILLER_17_725 VPWR VGND sg13g2_decap_8
XFILLER_16_257 VPWR VGND sg13g2_decap_8
XFILLER_44_599 VPWR VGND sg13g2_decap_8
XFILLER_31_216 VPWR VGND sg13g2_decap_8
XFILLER_32_739 VPWR VGND sg13g2_decap_8
X_2846__162 VPWR VGND net162 sg13g2_tiehi
XFILLER_25_791 VPWR VGND sg13g2_fill_2
XFILLER_13_964 VPWR VGND sg13g2_decap_8
XFILLER_9_957 VPWR VGND sg13g2_decap_8
XFILLER_8_456 VPWR VGND sg13g2_fill_2
XFILLER_4_684 VPWR VGND sg13g2_decap_8
XFILLER_3_172 VPWR VGND sg13g2_decap_8
X_1490_ _1192_ net333 net330 VPWR VGND sg13g2_nand2_1
XFILLER_12_4 VPWR VGND sg13g2_decap_8
X_2111_ net504 net284 _0615_ VPWR VGND sg13g2_nor2_1
Xhold1 falutop.div_inst.done VPWR VGND net175 sg13g2_dlygate4sd3_1
XFILLER_48_861 VPWR VGND sg13g2_decap_8
X_2042_ _0564_ _0559_ _0562_ VPWR VGND sg13g2_xnor2_1
XFILLER_23_717 VPWR VGND sg13g2_fill_2
X_2875_ net95 VGND VPWR _0096_ falutop.div_inst.b\[7\] clknet_5_8__leaf_clk sg13g2_dfrbpq_2
XFILLER_31_783 VPWR VGND sg13g2_fill_1
X_1826_ _0348_ _0351_ _0353_ VPWR VGND sg13g2_nor2_1
X_1757_ _0285_ _0259_ _0286_ VPWR VGND sg13g2_xor2_1
X_1688_ net350 net272 _0218_ VPWR VGND sg13g2_nor2_1
XFILLER_38_16 VPWR VGND sg13g2_decap_8
X_2309_ falutop.div_inst.b1\[3\] falutop.div_inst.acc\[3\] _0769_ VPWR VGND sg13g2_nor2b_1
XFILLER_38_382 VPWR VGND sg13g2_decap_4
XFILLER_26_566 VPWR VGND sg13g2_decap_8
XFILLER_26_599 VPWR VGND sg13g2_decap_4
XFILLER_13_238 VPWR VGND sg13g2_fill_1
XFILLER_6_916 VPWR VGND sg13g2_decap_8
XFILLER_10_956 VPWR VGND sg13g2_decap_8
XFILLER_5_448 VPWR VGND sg13g2_decap_8
XFILLER_1_665 VPWR VGND sg13g2_decap_8
XFILLER_49_636 VPWR VGND sg13g2_decap_8
XFILLER_0_175 VPWR VGND sg13g2_decap_8
XFILLER_29_360 VPWR VGND sg13g2_fill_2
XFILLER_17_555 VPWR VGND sg13g2_decap_8
XFILLER_45_875 VPWR VGND sg13g2_decap_8
XFILLER_44_363 VPWR VGND sg13g2_decap_8
XFILLER_17_566 VPWR VGND sg13g2_fill_2
XFILLER_32_536 VPWR VGND sg13g2_decap_8
XFILLER_32_569 VPWR VGND sg13g2_decap_8
XFILLER_8_220 VPWR VGND sg13g2_decap_4
XFILLER_9_754 VPWR VGND sg13g2_decap_8
X_2660_ net303 _1047_ _1048_ VPWR VGND sg13g2_nor2_1
X_1611_ _1309_ _1310_ _1311_ VPWR VGND sg13g2_nor2_1
X_2591_ net283 VPWR _0980_ VGND net368 net271 sg13g2_o21ai_1
XFILLER_5_53 VPWR VGND sg13g2_decap_8
X_1542_ _1243_ _1239_ _1240_ net308 _0926_ VPWR VGND sg13g2_a22oi_1
XFILLER_4_481 VPWR VGND sg13g2_decap_8
X_1473_ _1174_ _0925_ _1175_ VPWR VGND sg13g2_xor2_1
XFILLER_39_157 VPWR VGND sg13g2_fill_1
XFILLER_36_820 VPWR VGND sg13g2_decap_8
XFILLER_39_1003 VPWR VGND sg13g2_decap_8
X_2025_ net353 _0976_ _0548_ VPWR VGND sg13g2_nor2_1
XFILLER_36_864 VPWR VGND sg13g2_decap_4
XFILLER_23_569 VPWR VGND sg13g2_fill_1
XFILLER_40_39 VPWR VGND sg13g2_decap_8
X_2858_ net138 VGND VPWR net474 falutop.i2c_inst.result\[0\] clknet_5_18__leaf_clk
+ sg13g2_dfrbpq_1
Xhold220 falutop.data_in\[6\] VPWR VGND net521 sg13g2_dlygate4sd3_1
X_2789_ net94 VGND VPWR net237 falutop.div_inst.acc\[3\] clknet_5_2__leaf_clk sg13g2_dfrbpq_2
X_1809_ _0337_ _0300_ _0335_ VPWR VGND sg13g2_nand2b_1
XFILLER_45_105 VPWR VGND sg13g2_decap_4
XFILLER_39_691 VPWR VGND sg13g2_decap_8
XFILLER_38_190 VPWR VGND sg13g2_decap_8
XFILLER_27_831 VPWR VGND sg13g2_decap_4
XFILLER_26_341 VPWR VGND sg13g2_decap_8
XFILLER_26_352 VPWR VGND sg13g2_fill_1
XFILLER_27_875 VPWR VGND sg13g2_decap_8
XFILLER_42_856 VPWR VGND sg13g2_decap_8
XFILLER_41_322 VPWR VGND sg13g2_decap_4
XFILLER_14_525 VPWR VGND sg13g2_decap_8
XFILLER_22_580 VPWR VGND sg13g2_decap_8
XFILLER_10_753 VPWR VGND sg13g2_decap_8
XFILLER_14_95 VPWR VGND sg13g2_decap_8
XFILLER_6_713 VPWR VGND sg13g2_decap_8
XFILLER_5_201 VPWR VGND sg13g2_fill_1
XFILLER_5_267 VPWR VGND sg13g2_fill_1
XFILLER_49_400 VPWR VGND sg13g2_fill_1
XFILLER_2_963 VPWR VGND sg13g2_decap_8
XFILLER_1_462 VPWR VGND sg13g2_decap_8
XFILLER_49_433 VPWR VGND sg13g2_fill_2
XFILLER_37_628 VPWR VGND sg13g2_decap_8
XFILLER_18_853 VPWR VGND sg13g2_fill_2
XFILLER_36_127 VPWR VGND sg13g2_decap_8
XFILLER_17_363 VPWR VGND sg13g2_decap_8
XFILLER_33_889 VPWR VGND sg13g2_decap_8
X_2712_ VPWR VGND net303 net295 _1099_ _1046_ _1100_ _1048_ sg13g2_a221oi_1
X_2643_ _0983_ _1031_ _1032_ VPWR VGND sg13g2_nor2b_1
X_2574_ _0963_ net355 net330 VPWR VGND sg13g2_nand2b_1
X_1525_ _1215_ _1224_ _1226_ VPWR VGND sg13g2_nor2_1
XFILLER_35_39 VPWR VGND sg13g2_decap_8
X_2008_ _0490_ _0530_ _0531_ VPWR VGND sg13g2_nor2_1
XFILLER_23_311 VPWR VGND sg13g2_decap_8
XFILLER_23_322 VPWR VGND sg13g2_fill_1
XFILLER_13_1006 VPWR VGND sg13g2_decap_8
X_2914__111 VPWR VGND net111 sg13g2_tiehi
XFILLER_19_628 VPWR VGND sg13g2_fill_1
XFILLER_47_959 VPWR VGND sg13g2_decap_8
XFILLER_27_650 VPWR VGND sg13g2_fill_2
XFILLER_15_845 VPWR VGND sg13g2_decap_8
XFILLER_26_160 VPWR VGND sg13g2_decap_8
XFILLER_14_344 VPWR VGND sg13g2_decap_4
XFILLER_25_61 VPWR VGND sg13g2_decap_8
XFILLER_25_72 VPWR VGND sg13g2_fill_1
XFILLER_41_163 VPWR VGND sg13g2_fill_1
XFILLER_14_388 VPWR VGND sg13g2_fill_1
XFILLER_30_837 VPWR VGND sg13g2_decap_8
XFILLER_10_550 VPWR VGND sg13g2_decap_8
XFILLER_6_510 VPWR VGND sg13g2_decap_8
XFILLER_41_93 VPWR VGND sg13g2_decap_8
XFILLER_10_583 VPWR VGND sg13g2_decap_8
XFILLER_6_587 VPWR VGND sg13g2_decap_8
XFILLER_44_7 VPWR VGND sg13g2_decap_4
XFILLER_29_1002 VPWR VGND sg13g2_decap_8
XFILLER_2_760 VPWR VGND sg13g2_decap_8
X_2290_ net190 net275 _0754_ VPWR VGND sg13g2_nor2_1
XFILLER_2_32 VPWR VGND sg13g2_decap_8
XFILLER_38_959 VPWR VGND sg13g2_decap_8
XFILLER_37_458 VPWR VGND sg13g2_decap_8
XFILLER_46_981 VPWR VGND sg13g2_decap_8
XFILLER_20_303 VPWR VGND sg13g2_decap_4
XFILLER_32_152 VPWR VGND sg13g2_decap_8
XFILLER_20_369 VPWR VGND sg13g2_decap_8
X_2626_ VGND VPWR _0716_ _1014_ _1015_ _1012_ sg13g2_a21oi_1
X_2557_ _0946_ _0941_ _0944_ VPWR VGND sg13g2_nand2_2
X_1508_ _1210_ net307 _1154_ VPWR VGND sg13g2_nand2_1
Xclkbuf_5_7__f_clk clknet_4_3_0_clk clknet_5_7__leaf_clk VPWR VGND sg13g2_buf_8
X_2488_ net462 net414 _0736_ _0058_ VPWR VGND sg13g2_mux2_1
XFILLER_29_904 VPWR VGND sg13g2_decap_8
XFILLER_28_403 VPWR VGND sg13g2_decap_8
XFILLER_28_425 VPWR VGND sg13g2_fill_1
XFILLER_43_417 VPWR VGND sg13g2_decap_8
XFILLER_37_970 VPWR VGND sg13g2_decap_8
XFILLER_12_815 VPWR VGND sg13g2_decap_8
XFILLER_7_307 VPWR VGND sg13g2_decap_8
XFILLER_20_870 VPWR VGND sg13g2_fill_1
XFILLER_3_568 VPWR VGND sg13g2_decap_8
Xfanout382 net384 net382 VPWR VGND sg13g2_buf_8
Xfanout393 net394 net393 VPWR VGND sg13g2_buf_8
Xfanout360 falutop.alu_data_in\[3\] net360 VPWR VGND sg13g2_buf_8
Xfanout371 net372 net371 VPWR VGND sg13g2_buf_8
XFILLER_47_756 VPWR VGND sg13g2_decap_8
XFILLER_46_211 VPWR VGND sg13g2_decap_8
XFILLER_19_425 VPWR VGND sg13g2_fill_2
XFILLER_19_447 VPWR VGND sg13g2_decap_8
XFILLER_46_277 VPWR VGND sg13g2_decap_8
XFILLER_15_620 VPWR VGND sg13g2_fill_1
XFILLER_43_962 VPWR VGND sg13g2_decap_8
X_1790_ VPWR _0318_ _0317_ VGND sg13g2_inv_1
XFILLER_30_689 VPWR VGND sg13g2_fill_2
XFILLER_10_380 VPWR VGND sg13g2_decap_8
XFILLER_11_881 VPWR VGND sg13g2_decap_8
XFILLER_7_885 VPWR VGND sg13g2_decap_8
XFILLER_6_340 VPWR VGND sg13g2_decap_8
XFILLER_6_373 VPWR VGND sg13g2_fill_2
X_2411_ _0854_ _0853_ net436 _0852_ net297 VPWR VGND sg13g2_a22oi_1
X_2856__142 VPWR VGND net142 sg13g2_tiehi
X_2342_ _0799_ _0776_ _0777_ VPWR VGND sg13g2_xnor2_1
XFILLER_42_1010 VPWR VGND sg13g2_decap_8
XFILLER_38_723 VPWR VGND sg13g2_decap_8
X_2273_ VGND VPWR net376 net212 _0741_ _0740_ sg13g2_a21oi_1
XFILLER_38_756 VPWR VGND sg13g2_decap_8
X_2891__35 VPWR VGND net35 sg13g2_tiehi
XFILLER_19_970 VPWR VGND sg13g2_decap_8
XFILLER_25_406 VPWR VGND sg13g2_decap_4
XFILLER_37_288 VPWR VGND sg13g2_decap_8
XFILLER_34_995 VPWR VGND sg13g2_decap_8
XFILLER_32_18 VPWR VGND sg13g2_decap_8
XFILLER_20_177 VPWR VGND sg13g2_decap_8
X_1988_ net282 VPWR _0512_ VGND net356 _0976_ sg13g2_o21ai_1
X_2800__76 VPWR VGND net76 sg13g2_tiehi
X_2609_ _0998_ _0994_ _0997_ VPWR VGND sg13g2_nand2_1
Xclkbuf_4_5_0_clk clknet_0_clk clknet_4_5_0_clk VPWR VGND sg13g2_buf_8
XFILLER_29_701 VPWR VGND sg13g2_decap_8
XFILLER_28_288 VPWR VGND sg13g2_decap_8
XFILLER_43_247 VPWR VGND sg13g2_decap_8
XFILLER_25_951 VPWR VGND sg13g2_decap_8
XFILLER_19_1012 VPWR VGND sg13g2_decap_8
XFILLER_24_450 VPWR VGND sg13g2_fill_2
XFILLER_31_409 VPWR VGND sg13g2_decap_8
XFILLER_40_954 VPWR VGND sg13g2_decap_8
XFILLER_24_483 VPWR VGND sg13g2_fill_2
XFILLER_11_133 VPWR VGND sg13g2_fill_2
XFILLER_8_649 VPWR VGND sg13g2_decap_8
XFILLER_4_866 VPWR VGND sg13g2_decap_8
XFILLER_3_365 VPWR VGND sg13g2_decap_8
XFILLER_0_0 VPWR VGND sg13g2_decap_8
XFILLER_43_781 VPWR VGND sg13g2_decap_8
XFILLER_15_472 VPWR VGND sg13g2_fill_1
XFILLER_16_973 VPWR VGND sg13g2_decap_8
XFILLER_22_409 VPWR VGND sg13g2_fill_1
X_2891_ net35 VGND VPWR net526 falutop.alu_data_in\[15\] clknet_5_31__leaf_clk sg13g2_dfrbpq_1
X_1911_ net391 VPWR _0436_ VGND net451 net294 sg13g2_o21ai_1
XFILLER_15_483 VPWR VGND sg13g2_decap_8
X_1842_ _0368_ _0356_ _0369_ VPWR VGND sg13g2_nor2b_1
XFILLER_31_976 VPWR VGND sg13g2_decap_8
XFILLER_8_53 VPWR VGND sg13g2_decap_8
X_1773_ _0287_ VPWR _0301_ VGND _0259_ _0285_ sg13g2_o21ai_1
XFILLER_7_682 VPWR VGND sg13g2_decap_8
XFILLER_33_0 VPWR VGND sg13g2_decap_8
X_2325_ _0765_ _0784_ _0785_ VPWR VGND sg13g2_nor2_1
X_2256_ _0724_ net348 VPWR VGND sg13g2_inv_2
X_2187_ net388 VPWR _0669_ VGND net445 _0668_ sg13g2_o21ai_1
XFILLER_26_715 VPWR VGND sg13g2_fill_2
XFILLER_26_748 VPWR VGND sg13g2_decap_8
XFILLER_43_28 VPWR VGND sg13g2_decap_8
XFILLER_40_217 VPWR VGND sg13g2_decap_8
XFILLER_21_453 VPWR VGND sg13g2_decap_8
XFILLER_22_976 VPWR VGND sg13g2_decap_8
XFILLER_1_847 VPWR VGND sg13g2_decap_8
XFILLER_49_818 VPWR VGND sg13g2_decap_8
XFILLER_0_357 VPWR VGND sg13g2_decap_8
XFILLER_29_531 VPWR VGND sg13g2_decap_8
XFILLER_44_534 VPWR VGND sg13g2_decap_4
XFILLER_16_236 VPWR VGND sg13g2_decap_8
XFILLER_32_707 VPWR VGND sg13g2_decap_4
XFILLER_17_84 VPWR VGND sg13g2_fill_2
XFILLER_25_770 VPWR VGND sg13g2_decap_8
XFILLER_13_943 VPWR VGND sg13g2_decap_8
XFILLER_40_740 VPWR VGND sg13g2_fill_1
XFILLER_8_413 VPWR VGND sg13g2_decap_8
XFILLER_9_936 VPWR VGND sg13g2_decap_8
XFILLER_40_784 VPWR VGND sg13g2_decap_8
XFILLER_12_475 VPWR VGND sg13g2_fill_1
XFILLER_33_94 VPWR VGND sg13g2_decap_4
XFILLER_4_663 VPWR VGND sg13g2_decap_8
XFILLER_3_151 VPWR VGND sg13g2_decap_8
XFILLER_39_317 VPWR VGND sg13g2_decap_8
Xhold2 falutop.i2c_inst.state\[1\] VPWR VGND net176 sg13g2_dlygate4sd3_1
X_2110_ VGND VPWR _0719_ net284 _0110_ _0614_ sg13g2_a21oi_1
XFILLER_48_840 VPWR VGND sg13g2_decap_8
X_2041_ VGND VPWR _0563_ _0562_ _0559_ sg13g2_or2_1
XFILLER_35_512 VPWR VGND sg13g2_decap_8
XFILLER_35_523 VPWR VGND sg13g2_fill_1
XFILLER_47_394 VPWR VGND sg13g2_fill_1
XFILLER_31_762 VPWR VGND sg13g2_fill_2
X_2874_ net106 VGND VPWR _0095_ falutop.div_inst.a\[7\] clknet_5_6__leaf_clk sg13g2_dfrbpq_1
X_1825_ _0352_ _0348_ _0351_ VPWR VGND sg13g2_nand2_1
X_1756_ _0285_ _0270_ _0284_ VPWR VGND sg13g2_xnor2_1
X_1687_ _0216_ VPWR _0217_ VGND _0214_ _0215_ sg13g2_o21ai_1
X_2308_ falutop.div_inst.b1\[4\] falutop.div_inst.acc\[4\] _0768_ VPWR VGND sg13g2_nor2b_1
XFILLER_39_884 VPWR VGND sg13g2_decap_8
XFILLER_38_350 VPWR VGND sg13g2_fill_2
X_2239_ _0707_ net406 VPWR VGND sg13g2_inv_2
XFILLER_14_718 VPWR VGND sg13g2_decap_8
XFILLER_26_578 VPWR VGND sg13g2_decap_8
XFILLER_41_526 VPWR VGND sg13g2_decap_8
XFILLER_13_217 VPWR VGND sg13g2_decap_8
XFILLER_13_228 VPWR VGND sg13g2_fill_2
XFILLER_16_1015 VPWR VGND sg13g2_decap_8
XFILLER_10_935 VPWR VGND sg13g2_decap_8
XFILLER_1_644 VPWR VGND sg13g2_decap_8
XFILLER_49_615 VPWR VGND sg13g2_decap_8
XFILLER_0_154 VPWR VGND sg13g2_decap_8
XFILLER_48_125 VPWR VGND sg13g2_fill_1
XFILLER_48_136 VPWR VGND sg13g2_fill_2
XFILLER_48_169 VPWR VGND sg13g2_fill_1
XFILLER_17_501 VPWR VGND sg13g2_decap_8
XFILLER_45_854 VPWR VGND sg13g2_decap_8
XFILLER_17_578 VPWR VGND sg13g2_decap_8
XFILLER_44_397 VPWR VGND sg13g2_fill_1
XFILLER_32_548 VPWR VGND sg13g2_decap_4
XFILLER_13_751 VPWR VGND sg13g2_fill_1
XFILLER_9_733 VPWR VGND sg13g2_decap_8
XFILLER_12_283 VPWR VGND sg13g2_decap_8
XFILLER_12_294 VPWR VGND sg13g2_fill_2
X_1610_ _1310_ net335 net317 VPWR VGND sg13g2_nand2_1
X_2590_ _0977_ _0978_ _0979_ VPWR VGND sg13g2_nor2_1
XFILLER_5_994 VPWR VGND sg13g2_decap_8
XFILLER_5_32 VPWR VGND sg13g2_decap_8
XFILLER_4_460 VPWR VGND sg13g2_decap_8
X_1541_ VPWR _1242_ _1241_ VGND sg13g2_inv_1
XFILLER_5_98 VPWR VGND sg13g2_fill_1
X_1472_ _0927_ VPWR _1174_ VGND _0928_ _1140_ sg13g2_o21ai_1
X_2921__97 VPWR VGND net97 sg13g2_tiehi
X_2024_ VGND VPWR _0546_ _0547_ _0542_ _0508_ sg13g2_a21oi_2
XFILLER_48_692 VPWR VGND sg13g2_fill_1
XFILLER_23_504 VPWR VGND sg13g2_fill_2
XFILLER_23_548 VPWR VGND sg13g2_decap_8
XFILLER_31_570 VPWR VGND sg13g2_decap_8
X_2857_ net140 VGND VPWR _0078_ falutop.div_inst.rem\[7\] clknet_5_7__leaf_clk sg13g2_dfrbpq_2
X_1808_ _0336_ _0335_ _0300_ VPWR VGND sg13g2_nand2b_1
Xhold210 _0106_ VPWR VGND net511 sg13g2_dlygate4sd3_1
X_2788_ net96 VGND VPWR net225 falutop.div_inst.acc\[2\] clknet_5_3__leaf_clk sg13g2_dfrbpq_2
Xhold221 _0103_ VPWR VGND net522 sg13g2_dlygate4sd3_1
X_1739_ _0268_ _0260_ _0267_ VPWR VGND sg13g2_nand2_1
XFILLER_49_49 VPWR VGND sg13g2_decap_8
XFILLER_27_843 VPWR VGND sg13g2_decap_8
XFILLER_42_813 VPWR VGND sg13g2_decap_8
XFILLER_42_835 VPWR VGND sg13g2_decap_8
XFILLER_27_898 VPWR VGND sg13g2_fill_1
XFILLER_10_732 VPWR VGND sg13g2_decap_8
XFILLER_6_769 VPWR VGND sg13g2_decap_8
XFILLER_30_62 VPWR VGND sg13g2_decap_8
XFILLER_2_942 VPWR VGND sg13g2_decap_8
XFILLER_1_441 VPWR VGND sg13g2_decap_8
XFILLER_49_412 VPWR VGND sg13g2_decap_8
XFILLER_49_489 VPWR VGND sg13g2_decap_8
XFILLER_36_106 VPWR VGND sg13g2_fill_2
XFILLER_45_640 VPWR VGND sg13g2_decap_8
XFILLER_18_832 VPWR VGND sg13g2_decap_8
XFILLER_29_191 VPWR VGND sg13g2_decap_8
XFILLER_18_898 VPWR VGND sg13g2_decap_8
XFILLER_33_846 VPWR VGND sg13g2_decap_8
XFILLER_44_194 VPWR VGND sg13g2_decap_4
XFILLER_20_529 VPWR VGND sg13g2_fill_1
XFILLER_32_389 VPWR VGND sg13g2_fill_2
XFILLER_13_581 VPWR VGND sg13g2_decap_8
X_2711_ _1061_ _1072_ _1059_ _1099_ VPWR VGND _1098_ sg13g2_nand4_1
X_2642_ net343 net342 _1031_ VPWR VGND sg13g2_nor2_1
X_2573_ net324 net352 _0962_ VPWR VGND sg13g2_nor2b_1
XFILLER_5_791 VPWR VGND sg13g2_decap_8
X_1524_ _1225_ _1215_ _1224_ VPWR VGND sg13g2_nand2_1
XFILLER_28_618 VPWR VGND sg13g2_fill_2
X_2007_ _0530_ _0525_ _0529_ VPWR VGND sg13g2_xnor2_1
X_2866__122 VPWR VGND net122 sg13g2_tiehi
X_2909_ net131 VGND VPWR _0130_ falutop.i2c_inst.data_in\[2\] clknet_5_11__leaf_clk
+ sg13g2_dfrbpq_1
XFILLER_2_249 VPWR VGND sg13g2_decap_8
XFILLER_47_938 VPWR VGND sg13g2_decap_8
XFILLER_19_607 VPWR VGND sg13g2_decap_8
XFILLER_46_448 VPWR VGND sg13g2_decap_8
XFILLER_46_437 VPWR VGND sg13g2_fill_2
XFILLER_42_676 VPWR VGND sg13g2_decap_8
XFILLER_41_142 VPWR VGND sg13g2_decap_8
XFILLER_14_367 VPWR VGND sg13g2_decap_8
XFILLER_6_566 VPWR VGND sg13g2_decap_8
XFILLER_37_7 VPWR VGND sg13g2_decap_4
XFILLER_2_11 VPWR VGND sg13g2_decap_8
XFILLER_38_938 VPWR VGND sg13g2_decap_8
XFILLER_49_297 VPWR VGND sg13g2_fill_2
XFILLER_2_88 VPWR VGND sg13g2_decap_8
XFILLER_46_960 VPWR VGND sg13g2_decap_8
XFILLER_18_684 VPWR VGND sg13g2_decap_8
XFILLER_33_621 VPWR VGND sg13g2_decap_8
XFILLER_36_1018 VPWR VGND sg13g2_decap_8
XFILLER_20_337 VPWR VGND sg13g2_fill_1
X_2625_ _0977_ _1011_ _1014_ VPWR VGND sg13g2_nor2_2
X_2556_ _0941_ _0944_ _0945_ VPWR VGND sg13g2_nor2_1
X_1507_ _1186_ _1191_ _1158_ _1209_ VPWR VGND _1208_ sg13g2_nand4_1
X_2487_ VPWR _0057_ net428 VGND sg13g2_inv_1
X_2879__85 VPWR VGND net85 sg13g2_tiehi
XFILLER_46_39 VPWR VGND sg13g2_fill_1
XFILLER_46_28 VPWR VGND sg13g2_decap_8
XFILLER_28_459 VPWR VGND sg13g2_fill_2
XFILLER_23_153 VPWR VGND sg13g2_fill_1
XFILLER_24_687 VPWR VGND sg13g2_decap_8
XFILLER_20_893 VPWR VGND sg13g2_decap_8
XFILLER_3_547 VPWR VGND sg13g2_decap_8
XFILLER_2_4 VPWR VGND sg13g2_decap_8
Xfanout350 falutop.alu_data_in\[6\] net350 VPWR VGND sg13g2_buf_8
Xfanout372 net525 net372 VPWR VGND sg13g2_buf_8
Xfanout383 net384 net383 VPWR VGND sg13g2_buf_8
Xfanout361 net362 net361 VPWR VGND sg13g2_buf_8
XFILLER_47_735 VPWR VGND sg13g2_fill_2
Xfanout394 net395 net394 VPWR VGND sg13g2_buf_8
XFILLER_4_1027 VPWR VGND sg13g2_fill_2
XFILLER_34_407 VPWR VGND sg13g2_decap_8
XFILLER_28_982 VPWR VGND sg13g2_decap_8
XFILLER_43_941 VPWR VGND sg13g2_decap_8
XFILLER_14_153 VPWR VGND sg13g2_decap_8
XFILLER_14_164 VPWR VGND sg13g2_fill_1
XFILLER_15_698 VPWR VGND sg13g2_decap_4
XFILLER_11_860 VPWR VGND sg13g2_decap_8
XFILLER_7_864 VPWR VGND sg13g2_decap_8
X_2410_ net297 VPWR _0853_ VGND _0826_ _0829_ sg13g2_o21ai_1
X_2341_ _0798_ net230 net277 VPWR VGND sg13g2_nand2_1
X_2272_ _0707_ net376 _0740_ VPWR VGND sg13g2_nor2_1
XFILLER_38_702 VPWR VGND sg13g2_decap_8
XFILLER_38_779 VPWR VGND sg13g2_decap_8
XFILLER_37_267 VPWR VGND sg13g2_decap_8
XFILLER_34_974 VPWR VGND sg13g2_decap_8
XFILLER_20_101 VPWR VGND sg13g2_fill_1
XFILLER_21_646 VPWR VGND sg13g2_decap_8
X_1987_ net327 net272 _0511_ VPWR VGND sg13g2_nor2_1
X_2608_ _0996_ _0992_ _0985_ _0997_ VPWR VGND sg13g2_mux2_1
X_2539_ net337 net363 _0928_ VPWR VGND sg13g2_nor2_2
XFILLER_0_539 VPWR VGND sg13g2_decap_8
XFILLER_28_234 VPWR VGND sg13g2_decap_4
XFILLER_44_749 VPWR VGND sg13g2_decap_8
XFILLER_44_716 VPWR VGND sg13g2_decap_4
XFILLER_28_267 VPWR VGND sg13g2_decap_8
XFILLER_43_226 VPWR VGND sg13g2_decap_8
XFILLER_25_930 VPWR VGND sg13g2_decap_8
XFILLER_40_933 VPWR VGND sg13g2_decap_8
XFILLER_11_112 VPWR VGND sg13g2_decap_8
XFILLER_12_624 VPWR VGND sg13g2_decap_4
XFILLER_12_646 VPWR VGND sg13g2_decap_8
XFILLER_8_628 VPWR VGND sg13g2_decap_8
XFILLER_7_105 VPWR VGND sg13g2_decap_8
XFILLER_11_156 VPWR VGND sg13g2_fill_2
XFILLER_4_845 VPWR VGND sg13g2_decap_8
XFILLER_3_344 VPWR VGND sg13g2_decap_8
XFILLER_26_1028 VPWR VGND sg13g2_fill_1
XFILLER_47_532 VPWR VGND sg13g2_decap_8
XFILLER_47_510 VPWR VGND sg13g2_decap_8
XFILLER_19_223 VPWR VGND sg13g2_fill_1
XFILLER_47_93 VPWR VGND sg13g2_decap_8
XFILLER_16_952 VPWR VGND sg13g2_decap_8
XFILLER_43_760 VPWR VGND sg13g2_fill_1
X_2890_ net37 VGND VPWR net505 falutop.alu_data_in\[14\] clknet_5_21__leaf_clk sg13g2_dfrbpq_1
XFILLER_15_495 VPWR VGND sg13g2_decap_8
X_1910_ VGND VPWR _0430_ _0434_ _0089_ _0435_ sg13g2_a21oi_1
XFILLER_31_955 VPWR VGND sg13g2_decap_8
X_1841_ _0368_ _0359_ _0367_ VPWR VGND sg13g2_xnor2_1
XFILLER_8_32 VPWR VGND sg13g2_decap_8
XFILLER_30_465 VPWR VGND sg13g2_decap_4
XFILLER_7_661 VPWR VGND sg13g2_decap_8
X_1772_ VGND VPWR _0290_ _0300_ _0292_ _0291_ sg13g2_a21oi_2
XFILLER_6_193 VPWR VGND sg13g2_fill_1
X_2324_ VGND VPWR _0782_ _0783_ _0784_ _0766_ sg13g2_a21oi_1
X_2255_ VPWR _0723_ net369 VGND sg13g2_inv_1
X_2186_ _0657_ _0665_ _0668_ VPWR VGND sg13g2_nor2_1
XFILLER_38_598 VPWR VGND sg13g2_decap_8
XFILLER_22_955 VPWR VGND sg13g2_decap_8
XFILLER_5_609 VPWR VGND sg13g2_decap_8
XFILLER_49_1028 VPWR VGND sg13g2_fill_1
XFILLER_1_826 VPWR VGND sg13g2_decap_8
XFILLER_0_336 VPWR VGND sg13g2_decap_8
XFILLER_29_510 VPWR VGND sg13g2_decap_8
XFILLER_1_1008 VPWR VGND sg13g2_decap_8
XFILLER_17_63 VPWR VGND sg13g2_decap_8
XFILLER_44_568 VPWR VGND sg13g2_fill_2
XFILLER_13_922 VPWR VGND sg13g2_decap_8
XFILLER_25_793 VPWR VGND sg13g2_fill_1
XFILLER_40_763 VPWR VGND sg13g2_fill_1
XFILLER_40_752 VPWR VGND sg13g2_decap_8
XFILLER_9_915 VPWR VGND sg13g2_decap_8
XFILLER_13_999 VPWR VGND sg13g2_decap_8
XFILLER_32_1021 VPWR VGND sg13g2_decap_8
XFILLER_4_642 VPWR VGND sg13g2_decap_8
XFILLER_3_130 VPWR VGND sg13g2_decap_8
Xhold3 _0020_ VPWR VGND net177 sg13g2_dlygate4sd3_1
X_2040_ _0562_ _0489_ _0560_ VPWR VGND sg13g2_xnor2_1
XFILLER_48_896 VPWR VGND sg13g2_decap_8
XFILLER_35_535 VPWR VGND sg13g2_decap_8
XFILLER_35_579 VPWR VGND sg13g2_decap_4
XFILLER_16_771 VPWR VGND sg13g2_fill_1
XFILLER_16_782 VPWR VGND sg13g2_decap_8
XFILLER_15_281 VPWR VGND sg13g2_decap_8
XFILLER_15_292 VPWR VGND sg13g2_decap_8
X_2873_ net108 VGND VPWR net466 falutop.i2c_inst.result\[15\] clknet_5_28__leaf_clk
+ sg13g2_dfrbpq_1
X_1824_ VGND VPWR net363 _0261_ _0351_ _0349_ sg13g2_a21oi_1
Xclkbuf_4_4_0_clk clknet_0_clk clknet_4_4_0_clk VPWR VGND sg13g2_buf_8
XFILLER_8_992 VPWR VGND sg13g2_decap_8
X_1755_ _0282_ _0205_ _0284_ VPWR VGND sg13g2_xor2_1
X_1686_ VGND VPWR _0214_ _0215_ _0216_ _1019_ sg13g2_a21oi_1
X_2307_ falutop.div_inst.b1\[5\] falutop.div_inst.acc\[5\] _0767_ VPWR VGND sg13g2_nor2b_1
XFILLER_39_863 VPWR VGND sg13g2_decap_8
XFILLER_39_841 VPWR VGND sg13g2_fill_1
X_2238_ VPWR _0706_ net208 VGND sg13g2_inv_1
X_2169_ net386 VPWR _0656_ VGND net3 _0841_ sg13g2_o21ai_1
XFILLER_26_535 VPWR VGND sg13g2_decap_8
XFILLER_26_546 VPWR VGND sg13g2_fill_1
XFILLER_41_505 VPWR VGND sg13g2_decap_8
XFILLER_10_914 VPWR VGND sg13g2_decap_8
XFILLER_21_262 VPWR VGND sg13g2_decap_8
XFILLER_21_284 VPWR VGND sg13g2_decap_8
XFILLER_1_623 VPWR VGND sg13g2_decap_8
XFILLER_0_133 VPWR VGND sg13g2_decap_8
XFILLER_23_1009 VPWR VGND sg13g2_decap_8
XFILLER_28_62 VPWR VGND sg13g2_fill_1
XFILLER_45_833 VPWR VGND sg13g2_decap_8
XFILLER_44_354 VPWR VGND sg13g2_decap_4
XFILLER_32_505 VPWR VGND sg13g2_decap_8
XFILLER_44_83 VPWR VGND sg13g2_decap_8
XFILLER_9_712 VPWR VGND sg13g2_decap_8
XFILLER_12_262 VPWR VGND sg13g2_decap_8
XFILLER_13_796 VPWR VGND sg13g2_decap_8
XFILLER_8_266 VPWR VGND sg13g2_decap_8
XFILLER_9_789 VPWR VGND sg13g2_decap_8
XFILLER_5_11 VPWR VGND sg13g2_decap_8
X_1540_ net308 _1238_ _0926_ _1241_ VPWR VGND sg13g2_nand3_1
XFILLER_5_973 VPWR VGND sg13g2_decap_8
X_1471_ _1171_ _1172_ _1173_ VPWR VGND sg13g2_nor2_2
XFILLER_39_115 VPWR VGND sg13g2_decap_8
XFILLER_39_126 VPWR VGND sg13g2_fill_2
X_2023_ _0545_ net280 _0546_ VPWR VGND _0544_ sg13g2_nand3b_1
XFILLER_23_527 VPWR VGND sg13g2_decap_8
XFILLER_36_899 VPWR VGND sg13g2_decap_8
X_2925_ net109 VGND VPWR _0146_ falutop.i2c_inst.data_in\[18\] clknet_5_27__leaf_clk
+ sg13g2_dfrbpq_1
X_2856_ net142 VGND VPWR _0077_ falutop.div_inst.rem\[6\] clknet_5_1__leaf_clk sg13g2_dfrbpq_2
X_2899__157 VPWR VGND net157 sg13g2_tiehi
X_1807_ _0335_ _0301_ _0333_ VPWR VGND sg13g2_xnor2_1
X_2787_ net98 VGND VPWR net217 falutop.div_inst.acc\[1\] clknet_5_3__leaf_clk sg13g2_dfrbpq_2
Xhold200 falutop.div_inst.rem\[6\] VPWR VGND net501 sg13g2_dlygate4sd3_1
Xhold211 falutop.div_inst.rem\[0\] VPWR VGND net512 sg13g2_dlygate4sd3_1
Xhold222 falutop.data_in\[2\] VPWR VGND net523 sg13g2_dlygate4sd3_1
X_1738_ _0266_ _0188_ _0267_ VPWR VGND sg13g2_xor2_1
XFILLER_49_28 VPWR VGND sg13g2_decap_8
XFILLER_46_1009 VPWR VGND sg13g2_decap_8
X_1669_ _0197_ _1284_ _0199_ VPWR VGND sg13g2_xor2_1
XFILLER_27_822 VPWR VGND sg13g2_decap_4
XFILLER_41_379 VPWR VGND sg13g2_decap_8
XFILLER_10_711 VPWR VGND sg13g2_decap_8
XFILLER_22_560 VPWR VGND sg13g2_decap_4
XFILLER_10_788 VPWR VGND sg13g2_decap_8
XFILLER_6_748 VPWR VGND sg13g2_decap_8
XFILLER_30_30 VPWR VGND sg13g2_fill_2
XFILLER_30_41 VPWR VGND sg13g2_decap_4
XFILLER_2_921 VPWR VGND sg13g2_decap_8
XFILLER_1_420 VPWR VGND sg13g2_decap_8
XFILLER_7_1025 VPWR VGND sg13g2_decap_4
XFILLER_2_998 VPWR VGND sg13g2_decap_8
XFILLER_49_435 VPWR VGND sg13g2_fill_1
XFILLER_39_61 VPWR VGND sg13g2_decap_8
XFILLER_1_497 VPWR VGND sg13g2_decap_8
XFILLER_49_468 VPWR VGND sg13g2_decap_8
XFILLER_18_800 VPWR VGND sg13g2_decap_8
XFILLER_18_811 VPWR VGND sg13g2_fill_2
XFILLER_29_170 VPWR VGND sg13g2_decap_8
XFILLER_45_663 VPWR VGND sg13g2_decap_8
XFILLER_44_140 VPWR VGND sg13g2_decap_8
XFILLER_17_398 VPWR VGND sg13g2_decap_8
XFILLER_33_825 VPWR VGND sg13g2_decap_8
XFILLER_32_346 VPWR VGND sg13g2_decap_8
XFILLER_32_357 VPWR VGND sg13g2_fill_1
X_2710_ VPWR VGND _0985_ _1097_ _1093_ net281 _1098_ _1079_ sg13g2_a221oi_1
X_2641_ _1030_ _1004_ _0958_ VPWR VGND sg13g2_nand2b_1
X_2572_ _0957_ _0960_ _0956_ _0961_ VPWR VGND sg13g2_nand3_1
XFILLER_5_770 VPWR VGND sg13g2_decap_8
X_1523_ _1224_ _1221_ _1222_ VPWR VGND sg13g2_xnor2_1
XFILLER_4_280 VPWR VGND sg13g2_decap_8
X_2006_ _0528_ _0526_ _0529_ VPWR VGND sg13g2_xor2_1
XFILLER_23_302 VPWR VGND sg13g2_fill_1
XFILLER_36_674 VPWR VGND sg13g2_decap_8
XFILLER_36_685 VPWR VGND sg13g2_fill_2
XFILLER_35_184 VPWR VGND sg13g2_decap_8
X_2908_ net135 VGND VPWR _0129_ falutop.i2c_inst.data_in\[1\] clknet_5_11__leaf_clk
+ sg13g2_dfrbpq_1
X_2839_ net173 VGND VPWR _0060_ falutop.div_inst.b1\[6\] clknet_5_0__leaf_clk sg13g2_dfrbpq_1
XFILLER_3_729 VPWR VGND sg13g2_decap_8
XFILLER_2_228 VPWR VGND sg13g2_decap_8
XFILLER_47_917 VPWR VGND sg13g2_decap_8
XFILLER_46_416 VPWR VGND sg13g2_decap_8
XFILLER_15_814 VPWR VGND sg13g2_decap_4
XFILLER_27_674 VPWR VGND sg13g2_decap_8
XFILLER_14_324 VPWR VGND sg13g2_fill_1
XFILLER_26_195 VPWR VGND sg13g2_fill_2
XFILLER_41_198 VPWR VGND sg13g2_decap_8
XFILLER_23_880 VPWR VGND sg13g2_decap_8
XFILLER_23_891 VPWR VGND sg13g2_fill_2
XFILLER_6_545 VPWR VGND sg13g2_decap_8
XFILLER_2_795 VPWR VGND sg13g2_decap_8
XFILLER_1_294 VPWR VGND sg13g2_decap_8
XFILLER_49_243 VPWR VGND sg13g2_decap_8
XFILLER_38_917 VPWR VGND sg13g2_decap_8
XFILLER_2_67 VPWR VGND sg13g2_decap_8
XFILLER_49_276 VPWR VGND sg13g2_decap_8
XFILLER_18_663 VPWR VGND sg13g2_fill_2
XFILLER_33_611 VPWR VGND sg13g2_decap_4
XFILLER_21_839 VPWR VGND sg13g2_decap_8
X_2624_ VGND VPWR _1013_ _1011_ _0959_ sg13g2_or2_1
X_2555_ net350 net322 _0944_ VPWR VGND sg13g2_xor2_1
X_1506_ _1208_ _1207_ net281 _1160_ net283 VPWR VGND sg13g2_a22oi_1
X_2486_ _0897_ _0737_ net427 net412 net375 VPWR VGND sg13g2_a22oi_1
XFILLER_29_939 VPWR VGND sg13g2_decap_8
XFILLER_44_909 VPWR VGND sg13g2_decap_8
XFILLER_24_600 VPWR VGND sg13g2_fill_1
XFILLER_24_644 VPWR VGND sg13g2_decap_8
XFILLER_24_655 VPWR VGND sg13g2_fill_1
XFILLER_23_176 VPWR VGND sg13g2_decap_8
XFILLER_20_861 VPWR VGND sg13g2_decap_8
XFILLER_11_32 VPWR VGND sg13g2_fill_2
XFILLER_3_526 VPWR VGND sg13g2_decap_8
XFILLER_11_98 VPWR VGND sg13g2_decap_8
Xfanout340 net341 net340 VPWR VGND sg13g2_buf_1
Xfanout384 _0699_ net384 VPWR VGND sg13g2_buf_8
XFILLER_4_1006 VPWR VGND sg13g2_decap_8
Xfanout373 falutop.data_in\[7\] net373 VPWR VGND sg13g2_buf_8
Xfanout351 net352 net351 VPWR VGND sg13g2_buf_8
Xfanout362 net363 net362 VPWR VGND sg13g2_buf_8
Xfanout395 rst_n net395 VPWR VGND sg13g2_buf_8
XFILLER_46_246 VPWR VGND sg13g2_decap_8
XFILLER_28_961 VPWR VGND sg13g2_decap_8
XFILLER_43_920 VPWR VGND sg13g2_decap_8
XFILLER_15_611 VPWR VGND sg13g2_decap_8
XFILLER_36_62 VPWR VGND sg13g2_decap_4
XFILLER_27_493 VPWR VGND sg13g2_decap_8
XFILLER_43_997 VPWR VGND sg13g2_decap_8
XFILLER_42_441 VPWR VGND sg13g2_fill_1
XFILLER_14_132 VPWR VGND sg13g2_decap_8
XFILLER_14_176 VPWR VGND sg13g2_fill_2
XFILLER_14_187 VPWR VGND sg13g2_decap_4
XFILLER_30_658 VPWR VGND sg13g2_decap_8
XFILLER_7_843 VPWR VGND sg13g2_decap_8
XFILLER_6_320 VPWR VGND sg13g2_fill_1
XFILLER_6_375 VPWR VGND sg13g2_fill_1
X_2340_ _0794_ VPWR _0010_ VGND _0731_ _0797_ sg13g2_o21ai_1
XFILLER_2_592 VPWR VGND sg13g2_decap_8
X_2271_ _0739_ _0731_ _0737_ VPWR VGND sg13g2_nand2_2
XFILLER_28_4 VPWR VGND sg13g2_decap_8
XFILLER_37_246 VPWR VGND sg13g2_decap_8
XFILLER_26_909 VPWR VGND sg13g2_decap_8
XFILLER_18_493 VPWR VGND sg13g2_fill_1
XFILLER_34_953 VPWR VGND sg13g2_decap_8
XFILLER_21_625 VPWR VGND sg13g2_decap_4
X_1986_ _0509_ _0508_ _0510_ VPWR VGND sg13g2_nor2b_2
XFILLER_21_669 VPWR VGND sg13g2_decap_8
XFILLER_9_191 VPWR VGND sg13g2_decap_8
Xclkbuf_5_15__f_clk clknet_4_7_0_clk clknet_5_15__leaf_clk VPWR VGND sg13g2_buf_8
X_2607_ _0995_ VPWR _0996_ VGND _0718_ net274 sg13g2_o21ai_1
XFILLER_0_518 VPWR VGND sg13g2_decap_8
X_2538_ _0927_ net336 net361 VPWR VGND sg13g2_nand2_2
X_2469_ _0047_ _0721_ net285 net392 _0711_ VPWR VGND sg13g2_a22oi_1
XFILLER_29_747 VPWR VGND sg13g2_decap_8
XFILLER_44_706 VPWR VGND sg13g2_fill_2
XFILLER_44_739 VPWR VGND sg13g2_fill_2
XFILLER_43_205 VPWR VGND sg13g2_decap_8
XFILLER_16_408 VPWR VGND sg13g2_decap_8
XFILLER_37_791 VPWR VGND sg13g2_decap_8
XFILLER_40_912 VPWR VGND sg13g2_decap_8
XFILLER_25_986 VPWR VGND sg13g2_decap_8
XFILLER_36_290 VPWR VGND sg13g2_fill_2
XFILLER_40_989 VPWR VGND sg13g2_decap_8
XFILLER_8_607 VPWR VGND sg13g2_decap_8
XFILLER_7_139 VPWR VGND sg13g2_decap_8
X_2788__96 VPWR VGND net96 sg13g2_tiehi
XFILLER_4_824 VPWR VGND sg13g2_decap_8
XFILLER_22_97 VPWR VGND sg13g2_decap_4
XFILLER_3_323 VPWR VGND sg13g2_decap_8
XFILLER_26_1007 VPWR VGND sg13g2_decap_8
XFILLER_19_246 VPWR VGND sg13g2_decap_4
XFILLER_19_268 VPWR VGND sg13g2_decap_8
XFILLER_35_717 VPWR VGND sg13g2_decap_8
XFILLER_35_728 VPWR VGND sg13g2_fill_2
XFILLER_16_931 VPWR VGND sg13g2_decap_8
XFILLER_34_227 VPWR VGND sg13g2_decap_8
XFILLER_34_238 VPWR VGND sg13g2_fill_2
XFILLER_34_249 VPWR VGND sg13g2_decap_8
XFILLER_30_411 VPWR VGND sg13g2_decap_8
XFILLER_31_934 VPWR VGND sg13g2_decap_8
XFILLER_42_293 VPWR VGND sg13g2_decap_8
X_1840_ _0367_ _0360_ _0365_ VPWR VGND sg13g2_xnor2_1
XFILLER_8_11 VPWR VGND sg13g2_decap_8
XFILLER_8_88 VPWR VGND sg13g2_decap_4
XFILLER_7_640 VPWR VGND sg13g2_decap_8
X_1771_ VGND VPWR _0296_ _0299_ _0086_ _0238_ sg13g2_a21oi_1
XFILLER_30_499 VPWR VGND sg13g2_decap_8
XFILLER_6_161 VPWR VGND sg13g2_fill_2
XFILLER_3_890 VPWR VGND sg13g2_decap_8
X_2323_ _0783_ falutop.div_inst.b1\[6\] falutop.div_inst.acc\[6\] VPWR VGND sg13g2_xnor2_1
XFILLER_38_511 VPWR VGND sg13g2_fill_2
X_2254_ falutop.alu_inst.op\[2\] _0722_ VPWR VGND sg13g2_inv_4
X_2185_ VGND VPWR net382 _0666_ _0132_ _0667_ sg13g2_a21oi_1
XFILLER_38_577 VPWR VGND sg13g2_decap_4
XFILLER_41_709 VPWR VGND sg13g2_decap_8
XFILLER_22_934 VPWR VGND sg13g2_decap_8
XFILLER_21_488 VPWR VGND sg13g2_decap_8
X_1969_ _0492_ _0404_ _0493_ VPWR VGND sg13g2_xor2_1
XFILLER_49_1007 VPWR VGND sg13g2_decap_8
XFILLER_4_109 VPWR VGND sg13g2_decap_8
XFILLER_1_805 VPWR VGND sg13g2_decap_8
XFILLER_0_315 VPWR VGND sg13g2_decap_8
XFILLER_17_42 VPWR VGND sg13g2_decap_8
XFILLER_17_739 VPWR VGND sg13g2_decap_8
XFILLER_13_901 VPWR VGND sg13g2_decap_8
XFILLER_17_86 VPWR VGND sg13g2_fill_1
XFILLER_12_433 VPWR VGND sg13g2_fill_2
XFILLER_13_978 VPWR VGND sg13g2_decap_8
XFILLER_32_1000 VPWR VGND sg13g2_decap_8
XFILLER_4_621 VPWR VGND sg13g2_decap_8
XFILLER_4_698 VPWR VGND sg13g2_decap_8
XFILLER_3_186 VPWR VGND sg13g2_decap_8
Xhold4 falutop.div_inst.a\[1\] VPWR VGND net178 sg13g2_dlygate4sd3_1
XFILLER_0_882 VPWR VGND sg13g2_decap_8
XFILLER_48_875 VPWR VGND sg13g2_decap_8
XFILLER_47_352 VPWR VGND sg13g2_decap_8
XFILLER_31_742 VPWR VGND sg13g2_fill_1
X_2872_ net110 VGND VPWR net478 falutop.i2c_inst.result\[14\] clknet_5_24__leaf_clk
+ sg13g2_dfrbpq_1
X_1823_ _0350_ _0349_ VPWR VGND sg13g2_inv_2
XFILLER_30_296 VPWR VGND sg13g2_decap_8
XFILLER_8_971 VPWR VGND sg13g2_decap_8
X_1754_ _0205_ _0282_ _0283_ VPWR VGND sg13g2_nor2_1
X_1685_ VGND VPWR _1256_ _1302_ _0215_ _1301_ sg13g2_a21oi_1
X_2306_ falutop.div_inst.b1\[6\] falutop.div_inst.acc\[6\] _0766_ VPWR VGND sg13g2_nor2b_1
X_2237_ VPWR _0705_ net195 VGND sg13g2_inv_1
X_2168_ VGND VPWR net383 _0654_ _0127_ _0655_ sg13g2_a21oi_1
X_2099_ net517 net286 _0610_ VPWR VGND sg13g2_nor2_1
XFILLER_34_580 VPWR VGND sg13g2_fill_1
XFILLER_22_731 VPWR VGND sg13g2_fill_1
XFILLER_22_786 VPWR VGND sg13g2_decap_8
XFILLER_1_602 VPWR VGND sg13g2_decap_8
XFILLER_0_112 VPWR VGND sg13g2_decap_8
XFILLER_1_679 VPWR VGND sg13g2_decap_8
XFILLER_48_138 VPWR VGND sg13g2_fill_1
XFILLER_0_189 VPWR VGND sg13g2_decap_8
XFILLER_28_41 VPWR VGND sg13g2_decap_8
XFILLER_45_812 VPWR VGND sg13g2_decap_8
XFILLER_29_374 VPWR VGND sg13g2_decap_8
XFILLER_29_385 VPWR VGND sg13g2_fill_2
XFILLER_45_889 VPWR VGND sg13g2_decap_8
XFILLER_44_377 VPWR VGND sg13g2_decap_4
XFILLER_44_95 VPWR VGND sg13g2_fill_2
XFILLER_13_742 VPWR VGND sg13g2_decap_8
XFILLER_12_241 VPWR VGND sg13g2_decap_8
XFILLER_13_764 VPWR VGND sg13g2_fill_2
XFILLER_9_768 VPWR VGND sg13g2_decap_8
XFILLER_5_952 VPWR VGND sg13g2_decap_8
XFILLER_5_67 VPWR VGND sg13g2_decap_8
XFILLER_4_495 VPWR VGND sg13g2_decap_8
X_1470_ net280 VPWR _1172_ VGND _1134_ _1170_ sg13g2_o21ai_1
XFILLER_10_4 VPWR VGND sg13g2_decap_8
X_2022_ _0545_ _0506_ _0541_ VPWR VGND sg13g2_nand2_1
XFILLER_35_322 VPWR VGND sg13g2_decap_4
XFILLER_36_834 VPWR VGND sg13g2_decap_8
XFILLER_47_193 VPWR VGND sg13g2_fill_2
XFILLER_39_1028 VPWR VGND sg13g2_fill_1
XFILLER_39_1017 VPWR VGND sg13g2_decap_8
XFILLER_35_344 VPWR VGND sg13g2_decap_8
XFILLER_36_878 VPWR VGND sg13g2_decap_8
X_2924_ net141 VGND VPWR _0145_ falutop.i2c_inst.data_in\[17\] clknet_5_30__leaf_clk
+ sg13g2_dfrbpq_1
XFILLER_31_550 VPWR VGND sg13g2_fill_2
X_2855_ net144 VGND VPWR _0076_ falutop.div_inst.rem\[5\] clknet_5_18__leaf_clk sg13g2_dfrbpq_2
X_1806_ _0333_ _0301_ _0334_ VPWR VGND sg13g2_nor2b_1
X_2786_ net99 VGND VPWR net418 falutop.div_inst.acc\[0\] clknet_5_4__leaf_clk sg13g2_dfrbpq_2
Xhold201 falutop.data_in\[12\] VPWR VGND net502 sg13g2_dlygate4sd3_1
Xhold223 _0099_ VPWR VGND net524 sg13g2_dlygate4sd3_1
Xhold212 falutop.data_in\[10\] VPWR VGND net513 sg13g2_dlygate4sd3_1
X_1737_ _0266_ _0263_ _0264_ VPWR VGND sg13g2_xnor2_1
X_1668_ net356 _1284_ net337 _0198_ VPWR VGND sg13g2_nand3_1
X_1599_ _1299_ _1242_ _1296_ _1298_ VPWR VGND sg13g2_and3_1
XFILLER_46_609 VPWR VGND sg13g2_decap_8
XFILLER_27_801 VPWR VGND sg13g2_decap_8
XFILLER_39_683 VPWR VGND sg13g2_decap_4
XFILLER_26_311 VPWR VGND sg13g2_decap_8
XFILLER_26_322 VPWR VGND sg13g2_fill_1
XFILLER_27_867 VPWR VGND sg13g2_fill_2
XFILLER_27_889 VPWR VGND sg13g2_decap_8
X_2843__168 VPWR VGND net168 sg13g2_tiehi
XFILLER_22_594 VPWR VGND sg13g2_decap_8
XFILLER_6_727 VPWR VGND sg13g2_decap_8
XFILLER_10_767 VPWR VGND sg13g2_decap_8
XFILLER_5_237 VPWR VGND sg13g2_fill_1
XFILLER_2_900 VPWR VGND sg13g2_decap_8
XFILLER_7_1004 VPWR VGND sg13g2_decap_8
XFILLER_2_977 VPWR VGND sg13g2_decap_8
XFILLER_1_476 VPWR VGND sg13g2_decap_8
XFILLER_49_447 VPWR VGND sg13g2_decap_8
Xclkbuf_4_3_0_clk clknet_0_clk clknet_4_3_0_clk VPWR VGND sg13g2_buf_8
XFILLER_18_867 VPWR VGND sg13g2_decap_8
XFILLER_45_697 VPWR VGND sg13g2_decap_8
XFILLER_17_377 VPWR VGND sg13g2_fill_2
XFILLER_9_576 VPWR VGND sg13g2_decap_8
X_2640_ net327 _1028_ _1029_ VPWR VGND sg13g2_nor2_1
X_2571_ _0958_ _0959_ _0960_ VPWR VGND sg13g2_nor2_2
X_1522_ net321 _1221_ net336 _1223_ VPWR VGND sg13g2_nand3_1
XFILLER_4_270 VPWR VGND sg13g2_decap_4
XFILLER_27_119 VPWR VGND sg13g2_decap_8
X_2005_ VGND VPWR net349 net360 _0528_ _0527_ sg13g2_a21oi_1
XFILLER_24_804 VPWR VGND sg13g2_decap_8
XFILLER_36_653 VPWR VGND sg13g2_decap_4
X_2907_ net139 VGND VPWR net198 falutop.i2c_inst.data_in\[0\] clknet_5_14__leaf_clk
+ sg13g2_dfrbpq_1
XFILLER_32_881 VPWR VGND sg13g2_decap_8
X_2838_ net174 VGND VPWR _0059_ falutop.div_inst.b1\[5\] clknet_5_2__leaf_clk sg13g2_dfrbpq_1
XFILLER_3_708 VPWR VGND sg13g2_decap_8
X_2769_ VPWR VGND net304 net295 _1155_ net278 _1156_ _1152_ sg13g2_a221oi_1
XFILLER_2_207 VPWR VGND sg13g2_decap_8
XFILLER_41_100 VPWR VGND sg13g2_decap_8
XFILLER_15_859 VPWR VGND sg13g2_decap_8
XFILLER_26_174 VPWR VGND sg13g2_decap_8
XFILLER_41_41 VPWR VGND sg13g2_fill_2
XFILLER_10_542 VPWR VGND sg13g2_decap_4
XFILLER_10_564 VPWR VGND sg13g2_decap_4
XFILLER_6_524 VPWR VGND sg13g2_decap_8
XFILLER_29_1016 VPWR VGND sg13g2_decap_8
XFILLER_29_1027 VPWR VGND sg13g2_fill_2
XFILLER_2_774 VPWR VGND sg13g2_decap_8
XFILLER_49_222 VPWR VGND sg13g2_decap_8
XFILLER_49_211 VPWR VGND sg13g2_decap_8
XFILLER_1_273 VPWR VGND sg13g2_decap_8
XFILLER_37_406 VPWR VGND sg13g2_decap_8
XFILLER_2_46 VPWR VGND sg13g2_decap_8
XFILLER_18_631 VPWR VGND sg13g2_decap_4
XFILLER_46_995 VPWR VGND sg13g2_decap_8
X_2785__100 VPWR VGND net100 sg13g2_tiehi
XFILLER_33_656 VPWR VGND sg13g2_decap_8
XFILLER_21_807 VPWR VGND sg13g2_decap_8
XFILLER_14_892 VPWR VGND sg13g2_decap_8
XFILLER_20_328 VPWR VGND sg13g2_decap_8
XFILLER_32_166 VPWR VGND sg13g2_decap_8
X_2623_ _0959_ _1011_ _1012_ VPWR VGND sg13g2_nor2_2
X_2554_ net322 net350 _0943_ VPWR VGND sg13g2_nor2_1
XFILLER_49_0 VPWR VGND sg13g2_decap_8
X_1505_ _1206_ _1121_ _1207_ VPWR VGND sg13g2_xor2_1
X_2485_ net458 net268 _0736_ _0056_ VPWR VGND sg13g2_mux2_1
XFILLER_29_918 VPWR VGND sg13g2_decap_8
XFILLER_28_417 VPWR VGND sg13g2_fill_2
XFILLER_37_984 VPWR VGND sg13g2_decap_8
XFILLER_36_461 VPWR VGND sg13g2_fill_2
XFILLER_24_623 VPWR VGND sg13g2_decap_8
XFILLER_12_829 VPWR VGND sg13g2_decap_8
XFILLER_23_144 VPWR VGND sg13g2_decap_8
XFILLER_11_328 VPWR VGND sg13g2_decap_4
XFILLER_11_11 VPWR VGND sg13g2_decap_8
XFILLER_3_505 VPWR VGND sg13g2_decap_8
Xfanout341 net342 net341 VPWR VGND sg13g2_buf_8
Xfanout330 net331 net330 VPWR VGND sg13g2_buf_8
XFILLER_47_704 VPWR VGND sg13g2_fill_2
Xfanout363 falutop.alu_data_in\[2\] net363 VPWR VGND sg13g2_buf_8
Xfanout374 net378 net374 VPWR VGND sg13g2_buf_8
Xfanout352 net353 net352 VPWR VGND sg13g2_buf_8
XFILLER_47_737 VPWR VGND sg13g2_fill_1
Xfanout385 net395 net385 VPWR VGND sg13g2_buf_8
XFILLER_46_225 VPWR VGND sg13g2_decap_8
XFILLER_28_940 VPWR VGND sg13g2_decap_8
XFILLER_27_472 VPWR VGND sg13g2_fill_1
XFILLER_15_634 VPWR VGND sg13g2_decap_4
XFILLER_36_85 VPWR VGND sg13g2_decap_8
XFILLER_43_976 VPWR VGND sg13g2_decap_8
XFILLER_15_678 VPWR VGND sg13g2_fill_1
XFILLER_7_822 VPWR VGND sg13g2_decap_8
XFILLER_11_895 VPWR VGND sg13g2_decap_8
XFILLER_10_394 VPWR VGND sg13g2_decap_8
XFILLER_7_899 VPWR VGND sg13g2_decap_8
XFILLER_6_354 VPWR VGND sg13g2_fill_1
XFILLER_2_571 VPWR VGND sg13g2_decap_8
X_2270_ _0730_ _0736_ _0738_ VPWR VGND sg13g2_nor2_2
XFILLER_42_1024 VPWR VGND sg13g2_decap_4
XFILLER_37_203 VPWR VGND sg13g2_fill_2
XFILLER_37_225 VPWR VGND sg13g2_decap_8
XFILLER_19_984 VPWR VGND sg13g2_decap_8
XFILLER_46_792 VPWR VGND sg13g2_decap_8
XFILLER_33_420 VPWR VGND sg13g2_fill_2
XFILLER_34_932 VPWR VGND sg13g2_decap_8
XFILLER_21_604 VPWR VGND sg13g2_fill_2
XFILLER_20_114 VPWR VGND sg13g2_decap_4
X_1985_ net280 VPWR _0509_ VGND _0479_ _0507_ sg13g2_o21ai_1
XFILLER_20_147 VPWR VGND sg13g2_decap_8
X_2606_ _0995_ net334 net274 VPWR VGND sg13g2_nand2_1
X_2537_ net336 net361 _0926_ VPWR VGND sg13g2_and2_1
X_2468_ _0889_ net393 _0860_ VPWR VGND sg13g2_nand2_1
X_2399_ VGND VPWR _0842_ _0843_ _0022_ _0844_ sg13g2_a21oi_1
XFILLER_29_726 VPWR VGND sg13g2_decap_8
XFILLER_29_759 VPWR VGND sg13g2_decap_8
XFILLER_19_1026 VPWR VGND sg13g2_fill_2
XFILLER_25_965 VPWR VGND sg13g2_decap_8
XFILLER_40_968 VPWR VGND sg13g2_decap_8
XFILLER_7_129 VPWR VGND sg13g2_fill_1
XFILLER_11_158 VPWR VGND sg13g2_fill_1
XFILLER_22_32 VPWR VGND sg13g2_fill_2
XFILLER_22_43 VPWR VGND sg13g2_fill_2
XFILLER_20_681 VPWR VGND sg13g2_decap_4
XFILLER_20_692 VPWR VGND sg13g2_decap_8
XFILLER_4_803 VPWR VGND sg13g2_decap_8
XFILLER_3_302 VPWR VGND sg13g2_decap_8
XFILLER_3_379 VPWR VGND sg13g2_decap_8
XFILLER_47_62 VPWR VGND sg13g2_decap_8
XFILLER_47_589 VPWR VGND sg13g2_fill_2
XFILLER_47_578 VPWR VGND sg13g2_decap_8
XFILLER_16_910 VPWR VGND sg13g2_decap_8
Xclkbuf_5_21__f_clk clknet_4_10_0_clk clknet_5_21__leaf_clk VPWR VGND sg13g2_buf_8
XFILLER_16_987 VPWR VGND sg13g2_decap_8
XFILLER_27_291 VPWR VGND sg13g2_decap_8
XFILLER_43_795 VPWR VGND sg13g2_fill_2
XFILLER_42_272 VPWR VGND sg13g2_decap_8
X_2782__103 VPWR VGND net103 sg13g2_tiehi
XFILLER_31_913 VPWR VGND sg13g2_decap_8
XFILLER_30_445 VPWR VGND sg13g2_fill_2
XFILLER_8_67 VPWR VGND sg13g2_decap_8
X_1770_ VGND VPWR net304 _0298_ _0299_ net295 sg13g2_a21oi_1
XFILLER_11_692 VPWR VGND sg13g2_decap_8
XFILLER_7_696 VPWR VGND sg13g2_decap_8
X_2322_ _0781_ _0780_ _0767_ _0782_ VPWR VGND sg13g2_a21o_1
X_2253_ VPWR _0721_ falutop.alu_inst.op\[0\] VGND sg13g2_inv_1
X_2184_ net386 VPWR _0667_ VGND net252 _0666_ sg13g2_o21ai_1
XFILLER_38_534 VPWR VGND sg13g2_fill_1
XFILLER_38_523 VPWR VGND sg13g2_decap_8
XFILLER_22_913 VPWR VGND sg13g2_decap_8
XFILLER_21_423 VPWR VGND sg13g2_fill_2
XFILLER_21_467 VPWR VGND sg13g2_decap_4
X_1968_ _0492_ net347 net324 VPWR VGND sg13g2_nand2b_1
X_1899_ net280 VPWR _0425_ VGND _0422_ _0424_ sg13g2_o21ai_1
X_2839__173 VPWR VGND net173 sg13g2_tiehi
XFILLER_29_545 VPWR VGND sg13g2_fill_2
XFILLER_44_504 VPWR VGND sg13g2_fill_2
XFILLER_17_21 VPWR VGND sg13g2_decap_8
XFILLER_17_718 VPWR VGND sg13g2_decap_8
XFILLER_40_710 VPWR VGND sg13g2_fill_2
XFILLER_25_784 VPWR VGND sg13g2_decap_8
XFILLER_31_209 VPWR VGND sg13g2_decap_8
XFILLER_40_732 VPWR VGND sg13g2_fill_2
XFILLER_13_957 VPWR VGND sg13g2_decap_8
XFILLER_40_798 VPWR VGND sg13g2_decap_8
XFILLER_8_449 VPWR VGND sg13g2_decap_8
XFILLER_12_489 VPWR VGND sg13g2_decap_4
XFILLER_4_600 VPWR VGND sg13g2_decap_8
XFILLER_4_677 VPWR VGND sg13g2_decap_8
XFILLER_3_165 VPWR VGND sg13g2_decap_8
XFILLER_0_861 VPWR VGND sg13g2_decap_8
X_2853__148 VPWR VGND net148 sg13g2_tiehi
XFILLER_48_854 VPWR VGND sg13g2_decap_8
Xhold5 _0114_ VPWR VGND net179 sg13g2_dlygate4sd3_1
XFILLER_35_548 VPWR VGND sg13g2_decap_8
XFILLER_15_261 VPWR VGND sg13g2_fill_1
XFILLER_31_710 VPWR VGND sg13g2_decap_8
X_2871_ net112 VGND VPWR net472 falutop.i2c_inst.result\[13\] clknet_5_28__leaf_clk
+ sg13g2_dfrbpq_1
XFILLER_30_231 VPWR VGND sg13g2_decap_8
X_1822_ net318 VPWR _0349_ VGND net365 net362 sg13g2_o21ai_1
XFILLER_31_776 VPWR VGND sg13g2_fill_2
XFILLER_8_950 VPWR VGND sg13g2_decap_8
XFILLER_12_990 VPWR VGND sg13g2_decap_8
XFILLER_30_275 VPWR VGND sg13g2_fill_2
X_1753_ _0282_ _0276_ _0281_ VPWR VGND sg13g2_xnor2_1
XFILLER_7_493 VPWR VGND sg13g2_decap_8
X_1684_ _0214_ _0183_ _0212_ VPWR VGND sg13g2_xnor2_1
X_2790__92 VPWR VGND net92 sg13g2_tiehi
XFILLER_31_0 VPWR VGND sg13g2_decap_4
X_2305_ falutop.div_inst.acc\[7\] falutop.div_inst.b1\[7\] _0765_ VPWR VGND sg13g2_xor2_1
XFILLER_39_832 VPWR VGND sg13g2_decap_8
X_2236_ VPWR _0704_ net199 VGND sg13g2_inv_1
XFILLER_38_364 VPWR VGND sg13g2_fill_1
X_2167_ net393 VPWR _0655_ VGND net218 _0654_ sg13g2_o21ai_1
XFILLER_39_898 VPWR VGND sg13g2_decap_8
XFILLER_38_375 VPWR VGND sg13g2_decap_8
XFILLER_26_559 VPWR VGND sg13g2_decap_8
X_2098_ VGND VPWR _0725_ net285 _0103_ _0609_ sg13g2_a21oi_1
XFILLER_6_909 VPWR VGND sg13g2_decap_8
XFILLER_10_949 VPWR VGND sg13g2_decap_8
XFILLER_5_419 VPWR VGND sg13g2_fill_2
XFILLER_1_658 VPWR VGND sg13g2_decap_8
XFILLER_49_629 VPWR VGND sg13g2_decap_8
XFILLER_0_168 VPWR VGND sg13g2_decap_8
XFILLER_28_20 VPWR VGND sg13g2_decap_8
XFILLER_29_353 VPWR VGND sg13g2_decap_8
XFILLER_44_323 VPWR VGND sg13g2_fill_1
XFILLER_45_868 VPWR VGND sg13g2_decap_8
XFILLER_32_529 VPWR VGND sg13g2_decap_8
XFILLER_44_63 VPWR VGND sg13g2_fill_2
XFILLER_25_592 VPWR VGND sg13g2_decap_8
XFILLER_9_747 VPWR VGND sg13g2_decap_8
XFILLER_5_931 VPWR VGND sg13g2_decap_8
XFILLER_5_46 VPWR VGND sg13g2_decap_8
XFILLER_4_474 VPWR VGND sg13g2_decap_8
XFILLER_39_139 VPWR VGND sg13g2_fill_2
X_2021_ VPWR VGND _0462_ _0543_ _0478_ _0381_ _0544_ _0477_ sg13g2_a221oi_1
XFILLER_36_813 VPWR VGND sg13g2_decap_8
XFILLER_47_161 VPWR VGND sg13g2_decap_8
XFILLER_35_301 VPWR VGND sg13g2_decap_8
XFILLER_36_857 VPWR VGND sg13g2_decap_8
XFILLER_36_868 VPWR VGND sg13g2_fill_2
XFILLER_23_518 VPWR VGND sg13g2_decap_4
X_2923_ net117 VGND VPWR _0144_ falutop.i2c_inst.data_in\[16\] clknet_5_30__leaf_clk
+ sg13g2_dfrbpq_1
X_2854_ net146 VGND VPWR _0075_ falutop.div_inst.rem\[4\] clknet_5_6__leaf_clk sg13g2_dfrbpq_2
XFILLER_31_584 VPWR VGND sg13g2_decap_8
X_2785_ net100 VGND VPWR net193 falutop.div_inst.acc_next\[0\] clknet_5_4__leaf_clk
+ sg13g2_dfrbpq_1
X_1805_ _0333_ _0302_ _0332_ VPWR VGND sg13g2_xnor2_1
Xhold202 _0109_ VPWR VGND net503 sg13g2_dlygate4sd3_1
X_1736_ VGND VPWR _0265_ _0264_ _0263_ sg13g2_or2_1
Xhold224 falutop.data_in\[15\] VPWR VGND net525 sg13g2_dlygate4sd3_1
Xhold213 _0107_ VPWR VGND net514 sg13g2_dlygate4sd3_1
X_1667_ _0197_ net335 net354 VPWR VGND sg13g2_nand2_1
X_1598_ _1295_ _1294_ _1274_ _1298_ VPWR VGND sg13g2_a21o_1
XFILLER_22_1011 VPWR VGND sg13g2_decap_8
X_2219_ _0653_ _0684_ _0691_ VPWR VGND sg13g2_nor2_1
XFILLER_38_150 VPWR VGND sg13g2_decap_8
XFILLER_27_835 VPWR VGND sg13g2_fill_2
XFILLER_26_334 VPWR VGND sg13g2_decap_8
XFILLER_27_857 VPWR VGND sg13g2_decap_4
XFILLER_41_315 VPWR VGND sg13g2_decap_8
XFILLER_42_849 VPWR VGND sg13g2_decap_8
XFILLER_41_348 VPWR VGND sg13g2_fill_2
XFILLER_41_326 VPWR VGND sg13g2_fill_1
XFILLER_14_11 VPWR VGND sg13g2_decap_8
XFILLER_14_22 VPWR VGND sg13g2_fill_2
XFILLER_14_33 VPWR VGND sg13g2_fill_2
XFILLER_14_55 VPWR VGND sg13g2_decap_4
XFILLER_6_706 VPWR VGND sg13g2_decap_8
XFILLER_10_746 VPWR VGND sg13g2_decap_8
XFILLER_2_956 VPWR VGND sg13g2_decap_8
XFILLER_1_455 VPWR VGND sg13g2_decap_8
XFILLER_49_426 VPWR VGND sg13g2_decap_8
XFILLER_17_301 VPWR VGND sg13g2_decap_4
XFILLER_18_846 VPWR VGND sg13g2_decap_8
XFILLER_44_164 VPWR VGND sg13g2_fill_2
XFILLER_9_500 VPWR VGND sg13g2_fill_1
XFILLER_13_562 VPWR VGND sg13g2_decap_8
XFILLER_41_893 VPWR VGND sg13g2_decap_8
XFILLER_13_595 VPWR VGND sg13g2_decap_8
XFILLER_9_555 VPWR VGND sg13g2_fill_1
X_2570_ _0959_ falutop.alu_inst.op\[0\] falutop.alu_inst.op\[1\] VPWR VGND sg13g2_nand2_2
X_1521_ _1222_ net336 net321 VPWR VGND sg13g2_nand2_1
XFILLER_45_1022 VPWR VGND sg13g2_decap_8
XFILLER_49_993 VPWR VGND sg13g2_decap_8
X_2004_ net318 VPWR _0527_ VGND net349 net360 sg13g2_o21ai_1
X_2906_ net143 VGND VPWR _0127_ falutop.i2c_inst.data_in\[19\] clknet_5_30__leaf_clk
+ sg13g2_dfrbpq_1
XFILLER_31_381 VPWR VGND sg13g2_decap_8
X_2837_ net28 VGND VPWR _0058_ falutop.div_inst.b1\[4\] clknet_5_8__leaf_clk sg13g2_dfrbpq_1
X_2768_ _1155_ falutop.div_inst.val\[2\] _1153_ VPWR VGND sg13g2_xnor2_1
X_2699_ _1008_ _1014_ _0932_ _1087_ VPWR VGND sg13g2_mux2_1
X_1719_ _0247_ VPWR _0248_ VGND _0941_ _0246_ sg13g2_o21ai_1
XFILLER_27_643 VPWR VGND sg13g2_decap_8
Xclkbuf_5_2__f_clk clknet_4_1_0_clk clknet_5_2__leaf_clk VPWR VGND sg13g2_buf_8
XFILLER_26_153 VPWR VGND sg13g2_decap_8
XFILLER_41_123 VPWR VGND sg13g2_fill_2
XFILLER_14_337 VPWR VGND sg13g2_decap_8
XFILLER_15_838 VPWR VGND sg13g2_decap_8
XFILLER_25_32 VPWR VGND sg13g2_decap_8
XFILLER_25_43 VPWR VGND sg13g2_fill_2
XFILLER_25_54 VPWR VGND sg13g2_decap_8
XFILLER_41_156 VPWR VGND sg13g2_decap_8
XFILLER_14_348 VPWR VGND sg13g2_fill_2
XFILLER_30_808 VPWR VGND sg13g2_fill_1
XFILLER_10_521 VPWR VGND sg13g2_decap_8
XFILLER_6_503 VPWR VGND sg13g2_decap_8
XFILLER_2_753 VPWR VGND sg13g2_decap_8
XFILLER_1_252 VPWR VGND sg13g2_decap_8
XFILLER_2_25 VPWR VGND sg13g2_decap_8
XFILLER_46_974 VPWR VGND sg13g2_decap_8
XFILLER_45_473 VPWR VGND sg13g2_decap_4
XFILLER_17_164 VPWR VGND sg13g2_decap_8
XFILLER_17_175 VPWR VGND sg13g2_decap_4
XFILLER_18_698 VPWR VGND sg13g2_decap_8
XFILLER_32_123 VPWR VGND sg13g2_fill_1
XFILLER_33_635 VPWR VGND sg13g2_fill_1
XFILLER_14_871 VPWR VGND sg13g2_decap_8
XFILLER_9_363 VPWR VGND sg13g2_decap_4
X_2622_ _1011_ falutop.alu_inst.op\[2\] _0723_ VPWR VGND sg13g2_nand2_2
X_2553_ _0942_ net319 net349 VPWR VGND sg13g2_nand2_2
X_1504_ _1206_ _1192_ _1205_ VPWR VGND sg13g2_xnor2_1
X_2484_ net447 net242 _0736_ _0055_ VPWR VGND sg13g2_mux2_1
XFILLER_49_790 VPWR VGND sg13g2_decap_8
XFILLER_37_963 VPWR VGND sg13g2_decap_8
XFILLER_12_808 VPWR VGND sg13g2_decap_8
Xclkbuf_4_2_0_clk clknet_0_clk clknet_4_2_0_clk VPWR VGND sg13g2_buf_8
XFILLER_11_34 VPWR VGND sg13g2_fill_1
Xfanout320 net321 net320 VPWR VGND sg13g2_buf_8
Xfanout331 falutop.alu_data_in\[12\] net331 VPWR VGND sg13g2_buf_8
Xfanout342 falutop.alu_data_in\[9\] net342 VPWR VGND sg13g2_buf_8
Xfanout364 net366 net364 VPWR VGND sg13g2_buf_8
Xfanout375 net378 net375 VPWR VGND sg13g2_buf_1
Xfanout353 falutop.alu_data_in\[5\] net353 VPWR VGND sg13g2_buf_8
XFILLER_46_204 VPWR VGND sg13g2_decap_8
Xfanout386 net388 net386 VPWR VGND sg13g2_buf_8
X_2885__69 VPWR VGND net69 sg13g2_tiehi
XFILLER_47_749 VPWR VGND sg13g2_decap_8
XFILLER_28_996 VPWR VGND sg13g2_decap_8
XFILLER_43_955 VPWR VGND sg13g2_decap_8
XFILLER_14_123 VPWR VGND sg13g2_decap_4
XFILLER_15_657 VPWR VGND sg13g2_fill_2
XFILLER_7_801 VPWR VGND sg13g2_decap_8
XFILLER_23_690 VPWR VGND sg13g2_decap_8
XFILLER_11_874 VPWR VGND sg13g2_decap_8
XFILLER_10_373 VPWR VGND sg13g2_decap_8
XFILLER_7_878 VPWR VGND sg13g2_decap_8
XFILLER_6_366 VPWR VGND sg13g2_decap_8
XFILLER_6_388 VPWR VGND sg13g2_fill_2
XFILLER_2_550 VPWR VGND sg13g2_decap_8
XFILLER_35_7 VPWR VGND sg13g2_decap_8
XFILLER_42_1003 VPWR VGND sg13g2_decap_8
XFILLER_38_738 VPWR VGND sg13g2_decap_4
XFILLER_38_716 VPWR VGND sg13g2_decap_8
XFILLER_38_749 VPWR VGND sg13g2_decap_8
XFILLER_46_771 VPWR VGND sg13g2_decap_8
XFILLER_19_963 VPWR VGND sg13g2_decap_8
XFILLER_34_911 VPWR VGND sg13g2_decap_8
XFILLER_18_473 VPWR VGND sg13g2_decap_4
XFILLER_34_988 VPWR VGND sg13g2_decap_8
X_2863__128 VPWR VGND net128 sg13g2_tiehi
X_1984_ _0508_ _0479_ _0507_ VPWR VGND sg13g2_nand2_1
XFILLER_14_690 VPWR VGND sg13g2_decap_8
X_2904__147 VPWR VGND net147 sg13g2_tiehi
X_2605_ _0959_ _0978_ _0986_ _0994_ VPWR VGND sg13g2_nor3_2
X_2536_ net357 net334 _0925_ VPWR VGND sg13g2_xor2_1
X_2467_ _0714_ _0888_ _0046_ VPWR VGND sg13g2_nor2_1
X_2398_ net391 VPWR _0844_ VGND net381 net297 sg13g2_o21ai_1
XFILLER_28_204 VPWR VGND sg13g2_fill_2
XFILLER_24_410 VPWR VGND sg13g2_fill_2
XFILLER_25_944 VPWR VGND sg13g2_decap_8
XFILLER_19_1005 VPWR VGND sg13g2_decap_8
XFILLER_24_443 VPWR VGND sg13g2_decap_8
XFILLER_24_476 VPWR VGND sg13g2_decap_8
XFILLER_40_947 VPWR VGND sg13g2_decap_8
XFILLER_24_498 VPWR VGND sg13g2_decap_8
XFILLER_7_119 VPWR VGND sg13g2_fill_1
XFILLER_22_11 VPWR VGND sg13g2_decap_8
XFILLER_4_859 VPWR VGND sg13g2_decap_8
XFILLER_3_358 VPWR VGND sg13g2_decap_8
XFILLER_47_546 VPWR VGND sg13g2_decap_4
XFILLER_47_524 VPWR VGND sg13g2_decap_4
XFILLER_28_793 VPWR VGND sg13g2_decap_4
XFILLER_16_966 VPWR VGND sg13g2_decap_8
XFILLER_31_969 VPWR VGND sg13g2_decap_8
XFILLER_8_46 VPWR VGND sg13g2_decap_8
XFILLER_10_181 VPWR VGND sg13g2_fill_2
XFILLER_7_675 VPWR VGND sg13g2_decap_8
XFILLER_6_141 VPWR VGND sg13g2_decap_4
XFILLER_6_163 VPWR VGND sg13g2_fill_1
X_2321_ _0781_ falutop.div_inst.b1\[5\] falutop.div_inst.acc\[5\] VPWR VGND sg13g2_xnor2_1
X_2252_ net319 _0720_ VPWR VGND sg13g2_inv_4
X_2183_ _0840_ _0665_ _0666_ VPWR VGND sg13g2_nor2_1
XFILLER_26_708 VPWR VGND sg13g2_decap_8
XFILLER_19_782 VPWR VGND sg13g2_decap_4
XFILLER_18_292 VPWR VGND sg13g2_decap_4
XFILLER_21_413 VPWR VGND sg13g2_fill_1
XFILLER_34_796 VPWR VGND sg13g2_fill_1
XFILLER_22_969 VPWR VGND sg13g2_decap_8
XFILLER_33_295 VPWR VGND sg13g2_fill_2
X_1967_ _0449_ VPWR _0491_ VGND _0447_ _0450_ sg13g2_o21ai_1
XFILLER_30_980 VPWR VGND sg13g2_decap_8
X_1898_ _0423_ VPWR _0424_ VGND _0300_ _0380_ sg13g2_o21ai_1
X_2519_ VGND VPWR _0805_ net298 _0075_ _0911_ sg13g2_a21oi_1
XFILLER_29_524 VPWR VGND sg13g2_fill_1
XFILLER_44_538 VPWR VGND sg13g2_fill_2
XFILLER_44_527 VPWR VGND sg13g2_decap_8
XFILLER_17_77 VPWR VGND sg13g2_decap_8
XFILLER_13_936 VPWR VGND sg13g2_decap_8
XFILLER_24_262 VPWR VGND sg13g2_decap_8
XFILLER_12_435 VPWR VGND sg13g2_fill_1
XFILLER_24_295 VPWR VGND sg13g2_decap_8
XFILLER_33_32 VPWR VGND sg13g2_decap_8
XFILLER_33_43 VPWR VGND sg13g2_fill_2
XFILLER_40_777 VPWR VGND sg13g2_decap_8
XFILLER_8_406 VPWR VGND sg13g2_decap_8
XFILLER_9_929 VPWR VGND sg13g2_decap_8
XFILLER_33_98 VPWR VGND sg13g2_fill_1
XFILLER_4_656 VPWR VGND sg13g2_decap_8
XFILLER_3_144 VPWR VGND sg13g2_decap_8
XFILLER_0_840 VPWR VGND sg13g2_decap_8
XFILLER_48_833 VPWR VGND sg13g2_decap_8
Xhold6 falutop.div_inst.a\[5\] VPWR VGND net180 sg13g2_dlygate4sd3_1
XFILLER_47_332 VPWR VGND sg13g2_decap_4
XFILLER_35_505 VPWR VGND sg13g2_decap_8
XFILLER_43_560 VPWR VGND sg13g2_decap_8
XFILLER_15_240 VPWR VGND sg13g2_decap_8
XFILLER_15_251 VPWR VGND sg13g2_fill_2
XFILLER_43_582 VPWR VGND sg13g2_fill_2
X_2870_ net114 VGND VPWR net440 falutop.i2c_inst.result\[12\] clknet_5_25__leaf_clk
+ sg13g2_dfrbpq_1
X_1821_ _0316_ _0262_ _0314_ _0348_ VPWR VGND sg13g2_a21o_2
XFILLER_30_287 VPWR VGND sg13g2_decap_4
X_1752_ _0281_ _0203_ _0279_ VPWR VGND sg13g2_xnor2_1
XFILLER_7_472 VPWR VGND sg13g2_decap_8
X_1683_ _0213_ _0183_ _0212_ VPWR VGND sg13g2_nand2_1
XFILLER_39_811 VPWR VGND sg13g2_decap_8
X_2304_ _0764_ net216 net277 VPWR VGND sg13g2_nand2_1
X_2235_ VPWR _0703_ net186 VGND sg13g2_inv_1
X_2166_ _0652_ _0653_ _0654_ VPWR VGND sg13g2_nor2_1
XFILLER_39_877 VPWR VGND sg13g2_decap_8
XFILLER_38_343 VPWR VGND sg13g2_decap_8
X_2837__28 VPWR VGND net28 sg13g2_tiehi
XFILLER_0_1022 VPWR VGND sg13g2_decap_8
X_2097_ net521 net288 _0609_ VPWR VGND sg13g2_nor2_2
XFILLER_41_519 VPWR VGND sg13g2_decap_8
XFILLER_0_91 VPWR VGND sg13g2_decap_8
XFILLER_34_571 VPWR VGND sg13g2_decap_8
XFILLER_16_1008 VPWR VGND sg13g2_decap_8
XFILLER_21_221 VPWR VGND sg13g2_decap_4
XFILLER_22_722 VPWR VGND sg13g2_decap_8
XFILLER_34_593 VPWR VGND sg13g2_decap_8
XFILLER_10_928 VPWR VGND sg13g2_decap_8
XFILLER_22_755 VPWR VGND sg13g2_fill_2
XFILLER_21_276 VPWR VGND sg13g2_decap_4
XFILLER_21_298 VPWR VGND sg13g2_decap_8
XFILLER_1_637 VPWR VGND sg13g2_decap_8
XFILLER_49_608 VPWR VGND sg13g2_decap_8
XFILLER_0_147 VPWR VGND sg13g2_decap_8
XFILLER_29_343 VPWR VGND sg13g2_decap_4
XFILLER_45_847 VPWR VGND sg13g2_decap_8
XFILLER_44_302 VPWR VGND sg13g2_decap_8
XFILLER_32_519 VPWR VGND sg13g2_decap_4
XFILLER_13_722 VPWR VGND sg13g2_decap_8
XFILLER_44_97 VPWR VGND sg13g2_fill_1
XFILLER_40_552 VPWR VGND sg13g2_decap_8
XFILLER_9_726 VPWR VGND sg13g2_decap_8
XFILLER_12_276 VPWR VGND sg13g2_decap_8
XFILLER_5_910 VPWR VGND sg13g2_decap_8
XFILLER_5_25 VPWR VGND sg13g2_decap_8
XFILLER_5_987 VPWR VGND sg13g2_decap_8
XFILLER_4_453 VPWR VGND sg13g2_decap_8
X_2020_ _0543_ _0507_ _0541_ VPWR VGND sg13g2_nand2_1
XFILLER_48_663 VPWR VGND sg13g2_decap_8
XFILLER_47_195 VPWR VGND sg13g2_fill_1
XFILLER_36_847 VPWR VGND sg13g2_fill_1
XFILLER_35_379 VPWR VGND sg13g2_decap_4
X_2922_ net133 VGND VPWR _0143_ falutop.i2c_inst.data_in\[15\] clknet_5_15__leaf_clk
+ sg13g2_dfrbpq_1
XFILLER_16_593 VPWR VGND sg13g2_decap_8
XFILLER_31_552 VPWR VGND sg13g2_fill_1
XFILLER_31_563 VPWR VGND sg13g2_decap_8
X_2853_ net148 VGND VPWR _0074_ falutop.div_inst.rem\[3\] clknet_5_18__leaf_clk sg13g2_dfrbpq_2
X_1804_ _0332_ _0303_ _0330_ VPWR VGND sg13g2_xnor2_1
X_2784_ net101 VGND VPWR net189 falutop.div_inst.quo\[6\] clknet_5_5__leaf_clk sg13g2_dfrbpq_1
X_1735_ _0264_ net320 net365 VPWR VGND sg13g2_nand2_1
Xhold225 _0112_ VPWR VGND net526 sg13g2_dlygate4sd3_1
Xhold214 falutop.data_in\[5\] VPWR VGND net515 sg13g2_dlygate4sd3_1
XFILLER_7_280 VPWR VGND sg13g2_decap_8
Xhold203 falutop.data_in\[14\] VPWR VGND net504 sg13g2_dlygate4sd3_1
X_1666_ _0196_ net320 net367 VPWR VGND sg13g2_nand2_1
X_1597_ VGND VPWR _1294_ _1295_ _1297_ _1274_ sg13g2_a21oi_1
XFILLER_39_630 VPWR VGND sg13g2_decap_8
X_2218_ VGND VPWR net384 _0689_ _0142_ _0690_ sg13g2_a21oi_1
XFILLER_27_869 VPWR VGND sg13g2_fill_1
X_2149_ _0602_ net373 _0641_ VPWR VGND sg13g2_nor2b_1
XFILLER_10_725 VPWR VGND sg13g2_decap_8
XFILLER_5_206 VPWR VGND sg13g2_fill_2
XFILLER_30_55 VPWR VGND sg13g2_decap_8
XFILLER_30_99 VPWR VGND sg13g2_fill_1
XFILLER_2_935 VPWR VGND sg13g2_decap_8
XFILLER_1_434 VPWR VGND sg13g2_decap_8
XFILLER_49_405 VPWR VGND sg13g2_decap_8
XFILLER_18_825 VPWR VGND sg13g2_decap_8
X_2809__61 VPWR VGND net61 sg13g2_tiehi
XFILLER_45_633 VPWR VGND sg13g2_decap_8
XFILLER_29_184 VPWR VGND sg13g2_decap_8
XFILLER_45_677 VPWR VGND sg13g2_decap_4
XFILLER_17_379 VPWR VGND sg13g2_fill_1
XFILLER_44_198 VPWR VGND sg13g2_fill_1
XFILLER_33_839 VPWR VGND sg13g2_decap_8
XFILLER_13_541 VPWR VGND sg13g2_decap_8
XFILLER_41_872 VPWR VGND sg13g2_decap_8
XFILLER_40_360 VPWR VGND sg13g2_fill_2
XFILLER_9_512 VPWR VGND sg13g2_decap_8
XFILLER_5_784 VPWR VGND sg13g2_decap_8
X_1520_ _1221_ _1218_ _1219_ VPWR VGND sg13g2_xnor2_1
XFILLER_45_1001 VPWR VGND sg13g2_decap_8
XFILLER_4_294 VPWR VGND sg13g2_decap_4
XFILLER_49_972 VPWR VGND sg13g2_decap_8
XFILLER_36_611 VPWR VGND sg13g2_decap_8
X_2003_ net319 _0724_ _0526_ VPWR VGND sg13g2_nor2_1
XFILLER_36_622 VPWR VGND sg13g2_fill_1
XFILLER_35_198 VPWR VGND sg13g2_decap_4
XFILLER_36_699 VPWR VGND sg13g2_decap_8
XFILLER_32_861 VPWR VGND sg13g2_decap_8
X_2905_ net145 VGND VPWR net223 falutop.div_inst.b\[6\] clknet_5_8__leaf_clk sg13g2_dfrbpq_2
XFILLER_32_872 VPWR VGND sg13g2_fill_1
X_2836_ net29 VGND VPWR _0057_ falutop.div_inst.b1\[3\] clknet_5_3__leaf_clk sg13g2_dfrbpq_1
X_2842__170 VPWR VGND net170 sg13g2_tiehi
X_2767_ _1154_ _1153_ falutop.div_inst.val\[2\] VPWR VGND sg13g2_nand2b_1
X_2698_ _1083_ _1085_ _1086_ VPWR VGND sg13g2_nor2_1
X_1718_ VGND VPWR _0941_ _0246_ _0247_ _1089_ sg13g2_a21oi_1
X_1649_ _0179_ _0176_ _0177_ VPWR VGND sg13g2_xnor2_1
X_2873__108 VPWR VGND net108 sg13g2_tiehi
XFILLER_39_482 VPWR VGND sg13g2_decap_4
XFILLER_27_622 VPWR VGND sg13g2_decap_8
XFILLER_25_11 VPWR VGND sg13g2_decap_8
XFILLER_26_143 VPWR VGND sg13g2_fill_1
XFILLER_27_688 VPWR VGND sg13g2_decap_4
XFILLER_42_669 VPWR VGND sg13g2_decap_8
XFILLER_41_135 VPWR VGND sg13g2_decap_8
X_2806__64 VPWR VGND net64 sg13g2_tiehi
XFILLER_6_559 VPWR VGND sg13g2_decap_8
XFILLER_2_732 VPWR VGND sg13g2_decap_8
XFILLER_1_231 VPWR VGND sg13g2_decap_8
XFILLER_49_257 VPWR VGND sg13g2_fill_1
XFILLER_46_953 VPWR VGND sg13g2_decap_8
XFILLER_18_677 VPWR VGND sg13g2_fill_2
XFILLER_14_850 VPWR VGND sg13g2_decap_8
XFILLER_41_680 VPWR VGND sg13g2_fill_1
XFILLER_9_342 VPWR VGND sg13g2_decap_8
XFILLER_9_331 VPWR VGND sg13g2_fill_2
XFILLER_13_393 VPWR VGND sg13g2_decap_8
XFILLER_12_1011 VPWR VGND sg13g2_decap_8
X_2621_ VGND VPWR _1007_ _1009_ _1010_ _0922_ sg13g2_a21oi_1
X_2552_ _0938_ _0940_ _0941_ VPWR VGND sg13g2_nor2b_2
XFILLER_5_581 VPWR VGND sg13g2_decap_8
X_1503_ _1205_ _1193_ _1203_ VPWR VGND sg13g2_xnor2_1
X_2483_ VPWR _0054_ net239 VGND sg13g2_inv_1
XFILLER_28_419 VPWR VGND sg13g2_fill_1
XFILLER_37_942 VPWR VGND sg13g2_decap_8
XFILLER_36_463 VPWR VGND sg13g2_fill_1
XFILLER_36_474 VPWR VGND sg13g2_fill_2
XFILLER_20_886 VPWR VGND sg13g2_decap_8
X_2819_ net51 VGND VPWR net422 falutop.data_in\[12\] clknet_5_19__leaf_clk sg13g2_dfrbpq_2
Xfanout321 net322 net321 VPWR VGND sg13g2_buf_8
Xfanout332 net333 net332 VPWR VGND sg13g2_buf_8
Xfanout310 _0828_ net310 VPWR VGND sg13g2_buf_8
Xfanout343 net346 net343 VPWR VGND sg13g2_buf_8
Xfanout354 net355 net354 VPWR VGND sg13g2_buf_8
Xfanout365 net366 net365 VPWR VGND sg13g2_buf_1
XFILLER_47_728 VPWR VGND sg13g2_decap_8
Xfanout387 net388 net387 VPWR VGND sg13g2_buf_8
Xfanout376 net378 net376 VPWR VGND sg13g2_buf_8
XFILLER_28_975 VPWR VGND sg13g2_decap_8
XFILLER_43_934 VPWR VGND sg13g2_decap_8
XFILLER_14_102 VPWR VGND sg13g2_decap_8
XFILLER_14_146 VPWR VGND sg13g2_decap_8
XFILLER_42_488 VPWR VGND sg13g2_fill_1
XFILLER_35_1011 VPWR VGND sg13g2_decap_8
XFILLER_11_853 VPWR VGND sg13g2_decap_8
XFILLER_7_857 VPWR VGND sg13g2_decap_8
XFILLER_19_942 VPWR VGND sg13g2_decap_8
XFILLER_46_750 VPWR VGND sg13g2_decap_8
XFILLER_34_967 VPWR VGND sg13g2_decap_8
XFILLER_21_606 VPWR VGND sg13g2_fill_1
X_1983_ _0505_ _0480_ _0507_ VPWR VGND sg13g2_xor2_1
XFILLER_21_639 VPWR VGND sg13g2_decap_8
XFILLER_33_499 VPWR VGND sg13g2_decap_8
X_2604_ _0959_ _0978_ _0993_ VPWR VGND sg13g2_nor2_1
X_2535_ net332 net358 _0924_ VPWR VGND sg13g2_and2_1
X_2466_ VGND VPWR net375 _0735_ _0888_ net298 sg13g2_a21oi_1
X_2397_ VGND VPWR net1 _0826_ _0843_ _0839_ sg13g2_a21oi_1
XFILLER_28_238 VPWR VGND sg13g2_fill_1
XFILLER_37_761 VPWR VGND sg13g2_decap_4
XFILLER_43_219 VPWR VGND sg13g2_decap_8
XFILLER_24_400 VPWR VGND sg13g2_fill_2
XFILLER_25_923 VPWR VGND sg13g2_decap_8
XFILLER_40_926 VPWR VGND sg13g2_decap_8
XFILLER_11_105 VPWR VGND sg13g2_decap_8
XFILLER_12_617 VPWR VGND sg13g2_decap_8
XFILLER_19_1028 VPWR VGND sg13g2_fill_1
XFILLER_11_149 VPWR VGND sg13g2_decap_8
XFILLER_4_838 VPWR VGND sg13g2_decap_8
XFILLER_3_337 VPWR VGND sg13g2_fill_2
XFILLER_47_503 VPWR VGND sg13g2_fill_2
XFILLER_19_216 VPWR VGND sg13g2_decap_8
XFILLER_15_411 VPWR VGND sg13g2_decap_8
XFILLER_27_271 VPWR VGND sg13g2_fill_1
XFILLER_28_772 VPWR VGND sg13g2_fill_2
XFILLER_43_742 VPWR VGND sg13g2_decap_8
XFILLER_15_422 VPWR VGND sg13g2_fill_1
XFILLER_16_945 VPWR VGND sg13g2_decap_8
XFILLER_42_252 VPWR VGND sg13g2_decap_4
XFILLER_31_948 VPWR VGND sg13g2_decap_8
XFILLER_8_25 VPWR VGND sg13g2_decap_8
XFILLER_11_650 VPWR VGND sg13g2_decap_8
XFILLER_30_458 VPWR VGND sg13g2_decap_8
XFILLER_30_469 VPWR VGND sg13g2_fill_2
XFILLER_7_654 VPWR VGND sg13g2_decap_8
X_2320_ _0779_ _0778_ _0768_ _0780_ VPWR VGND sg13g2_a21o_1
X_2251_ _0719_ net323 VPWR VGND sg13g2_inv_2
XFILLER_26_4 VPWR VGND sg13g2_decap_8
X_2182_ _0665_ net379 _0833_ VPWR VGND sg13g2_nand2_2
Xclkbuf_4_1_0_clk clknet_0_clk clknet_4_1_0_clk VPWR VGND sg13g2_buf_8
XFILLER_18_271 VPWR VGND sg13g2_decap_8
XFILLER_21_425 VPWR VGND sg13g2_fill_1
XFILLER_22_948 VPWR VGND sg13g2_decap_8
XFILLER_33_285 VPWR VGND sg13g2_fill_1
X_1966_ _0490_ _0262_ _0487_ VPWR VGND sg13g2_xnor2_1
X_1897_ VGND VPWR _0334_ _0378_ _0423_ _0377_ sg13g2_a21oi_1
XFILLER_1_819 VPWR VGND sg13g2_decap_8
X_2518_ net385 VPWR _0911_ VGND net495 net298 sg13g2_o21ai_1
XFILLER_0_329 VPWR VGND sg13g2_decap_8
XFILLER_25_1021 VPWR VGND sg13g2_decap_8
XFILLER_29_503 VPWR VGND sg13g2_decap_8
X_2449_ _0870_ _0871_ falutop.i2c_inst.counter\[2\] _0873_ VPWR VGND _0872_ sg13g2_nand4_1
XFILLER_17_56 VPWR VGND sg13g2_decap_8
XFILLER_13_915 VPWR VGND sg13g2_decap_8
XFILLER_24_230 VPWR VGND sg13g2_fill_1
XFILLER_40_745 VPWR VGND sg13g2_decap_8
XFILLER_40_734 VPWR VGND sg13g2_fill_1
XFILLER_9_908 VPWR VGND sg13g2_decap_8
XFILLER_33_22 VPWR VGND sg13g2_fill_1
XFILLER_33_66 VPWR VGND sg13g2_fill_1
XFILLER_21_981 VPWR VGND sg13g2_decap_8
XFILLER_32_1014 VPWR VGND sg13g2_decap_8
XFILLER_4_635 VPWR VGND sg13g2_decap_8
XFILLER_3_123 VPWR VGND sg13g2_decap_8
XFILLER_48_812 VPWR VGND sg13g2_decap_8
XFILLER_47_311 VPWR VGND sg13g2_fill_2
Xhold7 _0118_ VPWR VGND net181 sg13g2_dlygate4sd3_1
XFILLER_0_896 VPWR VGND sg13g2_decap_8
XFILLER_48_889 VPWR VGND sg13g2_decap_8
XFILLER_35_528 VPWR VGND sg13g2_decap_8
XFILLER_28_591 VPWR VGND sg13g2_fill_1
XFILLER_15_274 VPWR VGND sg13g2_decap_8
XFILLER_16_797 VPWR VGND sg13g2_decap_8
XFILLER_30_211 VPWR VGND sg13g2_decap_8
X_1820_ _0328_ VPWR _0347_ VGND _0312_ _0329_ sg13g2_o21ai_1
XFILLER_31_778 VPWR VGND sg13g2_fill_1
XFILLER_7_451 VPWR VGND sg13g2_decap_8
XFILLER_11_480 VPWR VGND sg13g2_decap_8
X_1751_ _0203_ _0279_ _0280_ VPWR VGND sg13g2_nor2b_1
XFILLER_8_985 VPWR VGND sg13g2_decap_8
X_1682_ _0212_ _0184_ _0211_ VPWR VGND sg13g2_xnor2_1
X_2303_ VGND VPWR net276 _0762_ _0007_ _0763_ sg13g2_a21oi_1
XFILLER_39_801 VPWR VGND sg13g2_fill_1
X_2234_ VPWR _0702_ net190 VGND sg13g2_inv_1
X_2165_ net381 _0824_ net380 _0653_ VPWR VGND sg13g2_nand3_1
XFILLER_17_0 VPWR VGND sg13g2_decap_8
XFILLER_0_1001 VPWR VGND sg13g2_decap_8
XFILLER_26_528 VPWR VGND sg13g2_decap_8
XFILLER_0_70 VPWR VGND sg13g2_decap_8
X_2096_ net515 net353 net285 _0102_ VPWR VGND sg13g2_mux2_1
XFILLER_22_701 VPWR VGND sg13g2_decap_8
XFILLER_21_200 VPWR VGND sg13g2_decap_8
XFILLER_10_907 VPWR VGND sg13g2_decap_8
XFILLER_21_244 VPWR VGND sg13g2_decap_4
X_1949_ VGND VPWR net305 _0473_ _0474_ net296 sg13g2_a21oi_1
XFILLER_1_616 VPWR VGND sg13g2_decap_8
XFILLER_0_126 VPWR VGND sg13g2_decap_8
X_2852__150 VPWR VGND net150 sg13g2_tiehi
XFILLER_28_11 VPWR VGND sg13g2_decap_4
XFILLER_28_55 VPWR VGND sg13g2_decap_8
XFILLER_29_322 VPWR VGND sg13g2_decap_8
XFILLER_45_826 VPWR VGND sg13g2_decap_8
XFILLER_17_539 VPWR VGND sg13g2_fill_1
XFILLER_44_358 VPWR VGND sg13g2_fill_1
XFILLER_25_550 VPWR VGND sg13g2_decap_8
XFILLER_44_76 VPWR VGND sg13g2_decap_8
XFILLER_44_65 VPWR VGND sg13g2_fill_1
XFILLER_9_705 VPWR VGND sg13g2_decap_8
XFILLER_12_222 VPWR VGND sg13g2_fill_2
XFILLER_13_778 VPWR VGND sg13g2_decap_4
XFILLER_40_597 VPWR VGND sg13g2_decap_8
XFILLER_40_586 VPWR VGND sg13g2_fill_2
XFILLER_8_204 VPWR VGND sg13g2_fill_2
XFILLER_12_255 VPWR VGND sg13g2_decap_8
XFILLER_5_966 VPWR VGND sg13g2_decap_8
XFILLER_4_432 VPWR VGND sg13g2_decap_8
XFILLER_0_693 VPWR VGND sg13g2_decap_8
XFILLER_35_358 VPWR VGND sg13g2_fill_2
XFILLER_44_881 VPWR VGND sg13g2_decap_8
X_2921_ net97 VGND VPWR _0142_ falutop.i2c_inst.data_in\[14\] clknet_5_13__leaf_clk
+ sg13g2_dfrbpq_1
XFILLER_16_572 VPWR VGND sg13g2_decap_8
XFILLER_15_1020 VPWR VGND sg13g2_decap_8
X_2852_ net150 VGND VPWR _0073_ falutop.div_inst.rem\[2\] clknet_5_18__leaf_clk sg13g2_dfrbpq_2
X_1803_ _0303_ _0330_ _0331_ VPWR VGND sg13g2_nor2b_1
X_2783_ net102 VGND VPWR net191 falutop.div_inst.quo\[5\] clknet_5_4__leaf_clk sg13g2_dfrbpq_1
XFILLER_31_597 VPWR VGND sg13g2_decap_8
XFILLER_8_782 VPWR VGND sg13g2_decap_8
X_1734_ _0263_ net318 net367 VPWR VGND sg13g2_nand2_2
Xhold204 _0111_ VPWR VGND net505 sg13g2_dlygate4sd3_1
Xhold226 falutop.div_inst.start VPWR VGND net527 sg13g2_dlygate4sd3_1
Xhold215 _0102_ VPWR VGND net516 sg13g2_dlygate4sd3_1
X_1665_ _0195_ _1275_ _0194_ VPWR VGND sg13g2_xnor2_1
X_1596_ _1294_ _1295_ _1274_ _1296_ VPWR VGND sg13g2_nand3_1
X_2217_ net387 VPWR _0690_ VGND net430 _0689_ sg13g2_o21ai_1
XFILLER_27_815 VPWR VGND sg13g2_decap_8
X_2148_ net412 net292 _0640_ VPWR VGND sg13g2_nor2_1
X_2079_ _0599_ _0598_ falutop.data_in\[13\] VPWR VGND sg13g2_nand2b_1
XFILLER_14_509 VPWR VGND sg13g2_decap_4
X_2833__32 VPWR VGND net32 sg13g2_tiehi
XFILLER_35_892 VPWR VGND sg13g2_decap_8
XFILLER_14_35 VPWR VGND sg13g2_fill_1
XFILLER_22_553 VPWR VGND sg13g2_decap_8
XFILLER_10_704 VPWR VGND sg13g2_decap_8
XFILLER_14_68 VPWR VGND sg13g2_fill_2
XFILLER_5_218 VPWR VGND sg13g2_fill_2
XFILLER_30_23 VPWR VGND sg13g2_decap_8
XFILLER_30_45 VPWR VGND sg13g2_fill_1
XFILLER_2_914 VPWR VGND sg13g2_decap_8
XFILLER_1_413 VPWR VGND sg13g2_decap_8
XFILLER_7_1018 VPWR VGND sg13g2_decap_8
XFILLER_29_163 VPWR VGND sg13g2_decap_8
XFILLER_44_133 VPWR VGND sg13g2_decap_8
XFILLER_17_347 VPWR VGND sg13g2_decap_4
XFILLER_44_166 VPWR VGND sg13g2_fill_1
XFILLER_32_328 VPWR VGND sg13g2_decap_4
XFILLER_32_339 VPWR VGND sg13g2_decap_8
XFILLER_41_851 VPWR VGND sg13g2_decap_8
XFILLER_13_520 VPWR VGND sg13g2_decap_8
XFILLER_5_763 VPWR VGND sg13g2_decap_8
Xclkbuf_5_27__f_clk clknet_4_13_0_clk clknet_5_27__leaf_clk VPWR VGND sg13g2_buf_8
XFILLER_1_980 VPWR VGND sg13g2_decap_8
XFILLER_49_951 VPWR VGND sg13g2_decap_8
XFILLER_0_490 VPWR VGND sg13g2_decap_8
X_2002_ _0494_ VPWR _0525_ VGND _0404_ _0492_ sg13g2_o21ai_1
XFILLER_35_100 VPWR VGND sg13g2_fill_1
XFILLER_36_634 VPWR VGND sg13g2_fill_1
XFILLER_24_818 VPWR VGND sg13g2_decap_8
XFILLER_35_177 VPWR VGND sg13g2_decap_8
XFILLER_31_361 VPWR VGND sg13g2_decap_8
XFILLER_32_895 VPWR VGND sg13g2_decap_8
X_2904_ net147 VGND VPWR net426 falutop.div_inst.b\[5\] clknet_5_8__leaf_clk sg13g2_dfrbpq_1
X_2835_ net30 VGND VPWR _0056_ falutop.div_inst.b1\[2\] clknet_5_9__leaf_clk sg13g2_dfrbpq_1
X_2766_ net307 VPWR _1153_ VGND falutop.div_inst.val\[1\] falutop.div_inst.val\[0\]
+ sg13g2_o21ai_1
X_2697_ _1085_ net280 _1084_ VPWR VGND sg13g2_nand2_1
X_1717_ _0942_ VPWR _0246_ VGND _0943_ _0220_ sg13g2_o21ai_1
X_1648_ _0176_ _0177_ _0178_ VPWR VGND sg13g2_nor2_1
X_1579_ _1279_ _1278_ _1246_ VPWR VGND sg13g2_nand2b_1
XFILLER_46_409 VPWR VGND sg13g2_decap_8
XFILLER_15_807 VPWR VGND sg13g2_decap_8
XFILLER_27_667 VPWR VGND sg13g2_decap_8
XFILLER_42_637 VPWR VGND sg13g2_decap_8
XFILLER_14_317 VPWR VGND sg13g2_decap_8
XFILLER_26_188 VPWR VGND sg13g2_decap_8
XFILLER_41_125 VPWR VGND sg13g2_fill_1
XFILLER_23_851 VPWR VGND sg13g2_decap_8
XFILLER_22_372 VPWR VGND sg13g2_decap_4
XFILLER_41_88 VPWR VGND sg13g2_fill_1
XFILLER_6_538 VPWR VGND sg13g2_decap_8
XFILLER_2_711 VPWR VGND sg13g2_decap_8
XFILLER_1_210 VPWR VGND sg13g2_decap_8
XFILLER_2_788 VPWR VGND sg13g2_decap_8
X_2888__46 VPWR VGND net46 sg13g2_tiehi
XFILLER_49_236 VPWR VGND sg13g2_decap_8
XFILLER_1_287 VPWR VGND sg13g2_decap_8
XFILLER_49_269 VPWR VGND sg13g2_decap_8
XFILLER_18_601 VPWR VGND sg13g2_decap_8
XFILLER_46_932 VPWR VGND sg13g2_decap_8
XFILLER_17_133 VPWR VGND sg13g2_fill_2
XFILLER_18_656 VPWR VGND sg13g2_decap_8
XFILLER_33_604 VPWR VGND sg13g2_decap_8
XFILLER_33_615 VPWR VGND sg13g2_fill_1
XFILLER_13_372 VPWR VGND sg13g2_decap_8
X_2620_ VGND VPWR net281 _1003_ _1009_ _1008_ sg13g2_a21oi_1
X_2551_ _0940_ net315 net347 VPWR VGND sg13g2_nand2_1
XFILLER_5_560 VPWR VGND sg13g2_decap_8
X_1502_ _1204_ _1193_ _1203_ VPWR VGND sg13g2_nand2_1
X_2482_ _0896_ _0737_ net238 falutop.div_inst.b\[0\] net375 VPWR VGND sg13g2_a22oi_1
XFILLER_37_921 VPWR VGND sg13g2_decap_8
XFILLER_36_431 VPWR VGND sg13g2_fill_2
XFILLER_37_998 VPWR VGND sg13g2_decap_8
XFILLER_23_103 VPWR VGND sg13g2_decap_4
XFILLER_24_637 VPWR VGND sg13g2_decap_8
XFILLER_23_169 VPWR VGND sg13g2_decap_8
XFILLER_20_832 VPWR VGND sg13g2_decap_8
X_2818_ net52 VGND VPWR net241 falutop.data_in\[11\] clknet_5_26__leaf_clk sg13g2_dfrbpq_2
XFILLER_3_519 VPWR VGND sg13g2_decap_8
XFILLER_11_25 VPWR VGND sg13g2_decap_8
X_2749_ _1136_ _1135_ _1134_ VPWR VGND sg13g2_nand2b_1
Xfanout311 net312 net311 VPWR VGND sg13g2_buf_8
Xfanout300 _0887_ net300 VPWR VGND sg13g2_buf_8
Xfanout322 falutop.alu_data_in\[14\] net322 VPWR VGND sg13g2_buf_8
Xfanout344 net346 net344 VPWR VGND sg13g2_buf_8
Xfanout366 falutop.alu_data_in\[1\] net366 VPWR VGND sg13g2_buf_8
Xfanout333 falutop.alu_data_in\[11\] net333 VPWR VGND sg13g2_buf_8
Xfanout355 net356 net355 VPWR VGND sg13g2_buf_8
Xfanout388 net395 net388 VPWR VGND sg13g2_buf_8
Xclkbuf_5_10__f_clk clknet_4_5_0_clk clknet_5_10__leaf_clk VPWR VGND sg13g2_buf_8
Xfanout377 net378 net377 VPWR VGND sg13g2_buf_1
XFILLER_19_409 VPWR VGND sg13g2_decap_8
XFILLER_46_239 VPWR VGND sg13g2_decap_8
XFILLER_28_954 VPWR VGND sg13g2_decap_8
XFILLER_43_913 VPWR VGND sg13g2_decap_8
XFILLER_15_604 VPWR VGND sg13g2_decap_8
XFILLER_27_486 VPWR VGND sg13g2_decap_8
XFILLER_36_66 VPWR VGND sg13g2_fill_2
XFILLER_15_659 VPWR VGND sg13g2_fill_1
XFILLER_36_99 VPWR VGND sg13g2_decap_8
XFILLER_14_169 VPWR VGND sg13g2_decap_8
XFILLER_30_607 VPWR VGND sg13g2_decap_4
XFILLER_11_832 VPWR VGND sg13g2_decap_8
XFILLER_10_320 VPWR VGND sg13g2_decap_8
XFILLER_6_302 VPWR VGND sg13g2_decap_8
XFILLER_7_836 VPWR VGND sg13g2_decap_8
XFILLER_2_585 VPWR VGND sg13g2_decap_8
XFILLER_37_239 VPWR VGND sg13g2_decap_8
XFILLER_19_921 VPWR VGND sg13g2_decap_8
X_2884__71 VPWR VGND net71 sg13g2_tiehi
XFILLER_19_998 VPWR VGND sg13g2_decap_8
XFILLER_34_946 VPWR VGND sg13g2_decap_8
XFILLER_21_618 VPWR VGND sg13g2_decap_8
XFILLER_33_478 VPWR VGND sg13g2_fill_1
X_1982_ _0480_ _0505_ _0506_ VPWR VGND sg13g2_and2_1
XFILLER_13_191 VPWR VGND sg13g2_fill_2
XFILLER_9_184 VPWR VGND sg13g2_decap_8
X_2603_ _0991_ VPWR _0992_ VGND _0716_ net274 sg13g2_o21ai_1
X_2534_ net309 _0922_ _0923_ VPWR VGND sg13g2_nor2_2
XFILLER_47_0 VPWR VGND sg13g2_decap_8
X_2465_ _0728_ _0729_ _0887_ VPWR VGND sg13g2_nor2_2
X_2396_ _0842_ _0818_ _0837_ _0841_ VPWR VGND sg13g2_and3_2
XFILLER_3_81 VPWR VGND sg13g2_decap_8
XFILLER_25_902 VPWR VGND sg13g2_decap_8
XFILLER_37_784 VPWR VGND sg13g2_decap_8
XFILLER_40_905 VPWR VGND sg13g2_decap_8
XFILLER_24_456 VPWR VGND sg13g2_decap_4
XFILLER_25_979 VPWR VGND sg13g2_decap_8
XFILLER_20_651 VPWR VGND sg13g2_decap_8
XFILLER_4_817 VPWR VGND sg13g2_decap_8
XFILLER_3_316 VPWR VGND sg13g2_decap_8
XFILLER_47_21 VPWR VGND sg13g2_decap_8
XFILLER_47_76 VPWR VGND sg13g2_decap_8
XFILLER_28_751 VPWR VGND sg13g2_fill_2
XFILLER_16_924 VPWR VGND sg13g2_decap_8
XFILLER_31_927 VPWR VGND sg13g2_decap_8
XFILLER_42_286 VPWR VGND sg13g2_decap_8
X_2862__130 VPWR VGND net130 sg13g2_tiehi
XFILLER_7_633 VPWR VGND sg13g2_decap_8
XFILLER_10_183 VPWR VGND sg13g2_fill_1
XFILLER_6_154 VPWR VGND sg13g2_decap_8
XFILLER_40_7 VPWR VGND sg13g2_decap_8
XFILLER_3_883 VPWR VGND sg13g2_decap_8
XFILLER_2_382 VPWR VGND sg13g2_decap_8
X_2250_ net337 _0718_ VPWR VGND sg13g2_inv_4
X_2181_ VGND VPWR net382 _0663_ _0131_ _0664_ sg13g2_a21oi_1
XFILLER_19_4 VPWR VGND sg13g2_decap_8
XFILLER_22_927 VPWR VGND sg13g2_decap_8
XFILLER_34_765 VPWR VGND sg13g2_decap_4
XFILLER_33_297 VPWR VGND sg13g2_fill_1
X_1965_ _0489_ _0263_ _0487_ VPWR VGND sg13g2_xnor2_1
X_1896_ _0420_ _0421_ _0422_ VPWR VGND sg13g2_nor2_1
XFILLER_0_308 VPWR VGND sg13g2_decap_8
X_2517_ VGND VPWR _0801_ net299 _0074_ _0910_ sg13g2_a21oi_1
XFILLER_25_1000 VPWR VGND sg13g2_decap_8
X_2448_ _0872_ _0846_ falutop.i2c_inst.result\[5\] net310 falutop.i2c_inst.result\[4\]
+ VPWR VGND sg13g2_a22oi_1
X_2379_ _0824_ _0825_ _0826_ VPWR VGND sg13g2_nor2_2
XFILLER_17_35 VPWR VGND sg13g2_decap_8
XFILLER_25_710 VPWR VGND sg13g2_decap_8
XFILLER_25_743 VPWR VGND sg13g2_fill_2
XFILLER_33_45 VPWR VGND sg13g2_fill_1
XFILLER_21_960 VPWR VGND sg13g2_decap_8
XFILLER_20_470 VPWR VGND sg13g2_decap_8
XFILLER_4_614 VPWR VGND sg13g2_decap_8
XFILLER_3_102 VPWR VGND sg13g2_decap_8
XFILLER_3_179 VPWR VGND sg13g2_decap_8
Xclkbuf_5_8__f_clk clknet_4_4_0_clk clknet_5_8__leaf_clk VPWR VGND sg13g2_buf_8
XFILLER_0_875 VPWR VGND sg13g2_decap_8
Xhold8 falutop.div_inst.a\[2\] VPWR VGND net182 sg13g2_dlygate4sd3_1
XFILLER_48_868 VPWR VGND sg13g2_decap_8
XFILLER_47_345 VPWR VGND sg13g2_decap_8
XFILLER_16_710 VPWR VGND sg13g2_decap_8
XFILLER_43_584 VPWR VGND sg13g2_fill_1
XFILLER_31_724 VPWR VGND sg13g2_decap_4
XFILLER_30_245 VPWR VGND sg13g2_fill_2
X_1750_ _0278_ _0277_ _0279_ VPWR VGND sg13g2_xor2_1
XFILLER_8_964 VPWR VGND sg13g2_decap_8
XFILLER_7_430 VPWR VGND sg13g2_decap_8
X_1681_ _0209_ _0186_ _0211_ VPWR VGND sg13g2_xor2_1
XFILLER_48_1022 VPWR VGND sg13g2_decap_8
X_2302_ net417 net276 _0763_ VPWR VGND sg13g2_nor2_1
XFILLER_3_680 VPWR VGND sg13g2_decap_8
XFILLER_38_312 VPWR VGND sg13g2_decap_8
X_2233_ VPWR _0701_ net188 VGND sg13g2_inv_1
X_2164_ _0709_ net434 _0652_ VPWR VGND net436 sg13g2_nand3b_1
XFILLER_38_334 VPWR VGND sg13g2_fill_2
XFILLER_38_323 VPWR VGND sg13g2_fill_1
X_2095_ falutop.data_in\[4\] net453 net288 _0101_ VPWR VGND sg13g2_mux2_1
XFILLER_22_757 VPWR VGND sg13g2_fill_1
XFILLER_22_779 VPWR VGND sg13g2_decap_8
X_1948_ _0473_ falutop.div_inst.rem\[3\] _0472_ VPWR VGND sg13g2_xnor2_1
X_1879_ net334 net347 _0405_ VPWR VGND sg13g2_nor2b_2
X_2917__137 VPWR VGND net137 sg13g2_tiehi
XFILLER_0_105 VPWR VGND sg13g2_decap_8
XFILLER_28_34 VPWR VGND sg13g2_decap_8
XFILLER_45_805 VPWR VGND sg13g2_decap_8
XFILLER_29_367 VPWR VGND sg13g2_decap_8
XFILLER_44_22 VPWR VGND sg13g2_decap_4
XFILLER_12_234 VPWR VGND sg13g2_decap_8
XFILLER_5_945 VPWR VGND sg13g2_decap_8
XFILLER_4_411 VPWR VGND sg13g2_decap_8
Xclkbuf_4_0_0_clk clknet_0_clk clknet_4_0_0_clk VPWR VGND sg13g2_buf_8
XFILLER_4_488 VPWR VGND sg13g2_decap_8
XFILLER_48_610 VPWR VGND sg13g2_fill_2
XFILLER_0_672 VPWR VGND sg13g2_decap_8
XFILLER_36_827 VPWR VGND sg13g2_decap_8
XFILLER_47_186 VPWR VGND sg13g2_decap_8
X_2827__41 VPWR VGND net41 sg13g2_tiehi
XFILLER_35_315 VPWR VGND sg13g2_decap_8
XFILLER_35_326 VPWR VGND sg13g2_fill_1
XFILLER_44_860 VPWR VGND sg13g2_decap_8
XFILLER_16_540 VPWR VGND sg13g2_decap_4
XFILLER_16_551 VPWR VGND sg13g2_decap_8
X_2920_ net113 VGND VPWR _0141_ falutop.i2c_inst.data_in\[13\] clknet_5_14__leaf_clk
+ sg13g2_dfrbpq_1
XFILLER_31_543 VPWR VGND sg13g2_decap_8
X_2851_ net152 VGND VPWR net493 falutop.div_inst.rem\[1\] clknet_5_7__leaf_clk sg13g2_dfrbpq_2
X_1802_ _0329_ _0312_ _0330_ VPWR VGND sg13g2_xor2_1
X_2782_ net103 VGND VPWR net187 falutop.div_inst.quo\[4\] clknet_5_4__leaf_clk sg13g2_dfrbpq_1
XFILLER_8_761 VPWR VGND sg13g2_decap_8
XFILLER_7_260 VPWR VGND sg13g2_fill_2
X_1733_ net317 falutop.alu_data_in\[0\] _0262_ VPWR VGND sg13g2_and2_1
Xhold216 falutop.data_in\[7\] VPWR VGND net517 sg13g2_dlygate4sd3_1
Xhold205 falutop.alu_data_in\[8\] VPWR VGND net506 sg13g2_dlygate4sd3_1
XFILLER_7_293 VPWR VGND sg13g2_decap_8
X_1664_ _0192_ _0187_ _0194_ VPWR VGND sg13g2_xor2_1
X_1595_ _1293_ _1292_ _1282_ _1295_ VPWR VGND sg13g2_a21o_1
X_2216_ _0660_ _0684_ _0689_ VPWR VGND sg13g2_nor2_1
XFILLER_22_1025 VPWR VGND sg13g2_decap_4
XFILLER_39_676 VPWR VGND sg13g2_decap_8
XFILLER_38_164 VPWR VGND sg13g2_decap_4
XFILLER_26_304 VPWR VGND sg13g2_decap_8
X_2818__52 VPWR VGND net52 sg13g2_tiehi
XFILLER_39_698 VPWR VGND sg13g2_decap_8
XFILLER_38_197 VPWR VGND sg13g2_decap_4
X_2147_ VGND VPWR net291 _0639_ _0122_ _0638_ sg13g2_a21oi_1
X_2078_ falutop.data_in\[12\] _0597_ _0598_ VPWR VGND sg13g2_nor2b_1
XFILLER_26_348 VPWR VGND sg13g2_decap_4
XFILLER_34_370 VPWR VGND sg13g2_decap_8
XFILLER_22_587 VPWR VGND sg13g2_decap_8
XFILLER_5_208 VPWR VGND sg13g2_fill_1
XFILLER_1_469 VPWR VGND sg13g2_decap_8
XFILLER_44_112 VPWR VGND sg13g2_decap_8
XFILLER_26_882 VPWR VGND sg13g2_decap_8
XFILLER_25_381 VPWR VGND sg13g2_decap_4
XFILLER_25_392 VPWR VGND sg13g2_decap_8
XFILLER_40_395 VPWR VGND sg13g2_fill_1
XFILLER_9_569 VPWR VGND sg13g2_decap_8
XFILLER_5_742 VPWR VGND sg13g2_decap_8
XFILLER_4_274 VPWR VGND sg13g2_fill_2
XFILLER_4_252 VPWR VGND sg13g2_decap_8
XFILLER_49_930 VPWR VGND sg13g2_decap_8
X_2001_ _0496_ VPWR _0524_ VGND _0490_ _0497_ sg13g2_o21ai_1
XFILLER_36_646 VPWR VGND sg13g2_decap_8
XFILLER_23_318 VPWR VGND sg13g2_decap_4
X_2815__55 VPWR VGND net55 sg13g2_tiehi
X_2903_ net149 VGND VPWR net415 falutop.div_inst.b\[4\] clknet_5_8__leaf_clk sg13g2_dfrbpq_1
X_2834_ net31 VGND VPWR _0055_ falutop.div_inst.b1\[1\] clknet_5_6__leaf_clk sg13g2_dfrbpq_2
XFILLER_31_395 VPWR VGND sg13g2_decap_8
X_2765_ _1151_ VPWR _1152_ VGND _1106_ _1107_ sg13g2_o21ai_1
X_2696_ _1084_ _0920_ _0930_ VPWR VGND sg13g2_nand2_1
X_1716_ _0245_ net281 _0244_ VPWR VGND sg13g2_nand2_1
XFILLER_6_81 VPWR VGND sg13g2_fill_1
X_1647_ VGND VPWR _1306_ _1312_ _0177_ _1314_ sg13g2_a21oi_1
X_1578_ _1275_ _1277_ _1278_ VPWR VGND sg13g2_nor2_1
XFILLER_26_101 VPWR VGND sg13g2_fill_2
XFILLER_42_605 VPWR VGND sg13g2_fill_1
XFILLER_26_167 VPWR VGND sg13g2_decap_8
XFILLER_23_830 VPWR VGND sg13g2_decap_4
XFILLER_25_68 VPWR VGND sg13g2_decap_4
XFILLER_41_12 VPWR VGND sg13g2_decap_4
XFILLER_10_535 VPWR VGND sg13g2_decap_8
XFILLER_22_395 VPWR VGND sg13g2_decap_8
XFILLER_41_34 VPWR VGND sg13g2_decap_8
XFILLER_10_557 VPWR VGND sg13g2_decap_8
XFILLER_6_517 VPWR VGND sg13g2_decap_8
XFILLER_10_568 VPWR VGND sg13g2_fill_2
XFILLER_29_1009 VPWR VGND sg13g2_decap_8
XFILLER_2_767 VPWR VGND sg13g2_decap_8
XFILLER_49_204 VPWR VGND sg13g2_decap_8
XFILLER_1_266 VPWR VGND sg13g2_decap_8
XFILLER_2_39 VPWR VGND sg13g2_decap_8
XFILLER_46_911 VPWR VGND sg13g2_decap_8
XFILLER_18_635 VPWR VGND sg13g2_fill_1
XFILLER_46_988 VPWR VGND sg13g2_decap_8
XFILLER_33_649 VPWR VGND sg13g2_decap_8
XFILLER_14_885 VPWR VGND sg13g2_decap_8
XFILLER_32_159 VPWR VGND sg13g2_decap_8
X_2812__58 VPWR VGND net58 sg13g2_tiehi
XFILLER_9_311 VPWR VGND sg13g2_decap_4
X_2550_ _0939_ _0938_ VPWR VGND sg13g2_inv_2
X_2481_ VGND VPWR _0708_ _0893_ _0053_ net374 sg13g2_a21oi_1
X_1501_ _1202_ _1194_ _1203_ VPWR VGND sg13g2_xor2_1
X_2872__110 VPWR VGND net110 sg13g2_tiehi
XFILLER_37_900 VPWR VGND sg13g2_decap_8
XFILLER_37_977 VPWR VGND sg13g2_decap_8
XFILLER_36_454 VPWR VGND sg13g2_decap_8
XFILLER_24_616 VPWR VGND sg13g2_decap_8
XFILLER_23_137 VPWR VGND sg13g2_decap_8
XFILLER_20_811 VPWR VGND sg13g2_fill_2
XFILLER_32_693 VPWR VGND sg13g2_decap_8
X_2817_ net53 VGND VPWR net256 falutop.data_in\[10\] clknet_5_27__leaf_clk sg13g2_dfrbpq_2
X_2748_ VGND VPWR _1084_ _1133_ _1135_ _1019_ sg13g2_a21oi_1
X_2679_ _1067_ net327 _0990_ VPWR VGND sg13g2_nand2_1
Xfanout312 _0819_ net312 VPWR VGND sg13g2_buf_8
Xfanout301 net302 net301 VPWR VGND sg13g2_buf_8
Xfanout323 net326 net323 VPWR VGND sg13g2_buf_8
Xfanout345 net346 net345 VPWR VGND sg13g2_buf_2
Xfanout334 falutop.alu_data_in\[11\] net334 VPWR VGND sg13g2_buf_8
Xfanout356 falutop.alu_data_in\[4\] net356 VPWR VGND sg13g2_buf_8
Xfanout378 net527 net378 VPWR VGND sg13g2_buf_8
Xfanout367 net368 net367 VPWR VGND sg13g2_buf_8
Xfanout389 net395 net389 VPWR VGND sg13g2_buf_8
XFILLER_46_218 VPWR VGND sg13g2_decap_8
XFILLER_28_933 VPWR VGND sg13g2_decap_8
XFILLER_39_281 VPWR VGND sg13g2_decap_8
XFILLER_27_432 VPWR VGND sg13g2_fill_2
XFILLER_36_34 VPWR VGND sg13g2_fill_1
XFILLER_15_627 VPWR VGND sg13g2_decap_8
XFILLER_27_465 VPWR VGND sg13g2_decap_8
XFILLER_43_969 VPWR VGND sg13g2_decap_8
X_2849__156 VPWR VGND net156 sg13g2_tiehi
XFILLER_15_638 VPWR VGND sg13g2_fill_1
XFILLER_30_619 VPWR VGND sg13g2_decap_4
XFILLER_11_811 VPWR VGND sg13g2_decap_8
XFILLER_7_815 VPWR VGND sg13g2_decap_8
XFILLER_6_325 VPWR VGND sg13g2_decap_4
XFILLER_11_888 VPWR VGND sg13g2_decap_8
XFILLER_10_387 VPWR VGND sg13g2_decap_8
XFILLER_6_347 VPWR VGND sg13g2_decap_8
XFILLER_7_0 VPWR VGND sg13g2_decap_8
X_2895__165 VPWR VGND net165 sg13g2_tiehi
XFILLER_2_564 VPWR VGND sg13g2_decap_8
XFILLER_42_1017 VPWR VGND sg13g2_decap_8
XFILLER_42_1028 VPWR VGND sg13g2_fill_1
XFILLER_19_900 VPWR VGND sg13g2_decap_8
XFILLER_18_421 VPWR VGND sg13g2_fill_1
XFILLER_19_977 VPWR VGND sg13g2_decap_8
XFILLER_46_785 VPWR VGND sg13g2_decap_8
XFILLER_34_925 VPWR VGND sg13g2_decap_8
XFILLER_45_284 VPWR VGND sg13g2_decap_4
XFILLER_33_413 VPWR VGND sg13g2_decap_8
X_1981_ _0505_ _0439_ _0503_ VPWR VGND sg13g2_xnor2_1
XFILLER_20_107 VPWR VGND sg13g2_decap_8
XFILLER_20_118 VPWR VGND sg13g2_fill_1
X_2602_ _0991_ net338 net274 VPWR VGND sg13g2_nand2_1
XFILLER_6_881 VPWR VGND sg13g2_decap_8
X_2533_ net343 net368 _0922_ VPWR VGND sg13g2_nor2_1
X_2464_ VPWR _0045_ _0886_ VGND sg13g2_inv_1
X_2395_ net310 _0834_ _0824_ _0841_ VPWR VGND sg13g2_nand3_1
XFILLER_3_60 VPWR VGND sg13g2_decap_8
XFILLER_29_708 VPWR VGND sg13g2_fill_1
XFILLER_37_752 VPWR VGND sg13g2_decap_4
XFILLER_36_240 VPWR VGND sg13g2_fill_1
XFILLER_25_958 VPWR VGND sg13g2_decap_8
XFILLER_19_1019 VPWR VGND sg13g2_decap_8
XFILLER_33_980 VPWR VGND sg13g2_decap_8
XFILLER_22_25 VPWR VGND sg13g2_decap_8
XFILLER_20_674 VPWR VGND sg13g2_decap_8
XFILLER_20_685 VPWR VGND sg13g2_fill_2
XFILLER_3_339 VPWR VGND sg13g2_fill_1
XFILLER_0_7 VPWR VGND sg13g2_decap_8
XFILLER_47_505 VPWR VGND sg13g2_fill_1
XFILLER_16_903 VPWR VGND sg13g2_decap_8
XFILLER_27_240 VPWR VGND sg13g2_decap_4
XFILLER_27_262 VPWR VGND sg13g2_decap_8
XFILLER_27_284 VPWR VGND sg13g2_decap_8
XFILLER_15_468 VPWR VGND sg13g2_decap_4
XFILLER_31_906 VPWR VGND sg13g2_decap_8
XFILLER_43_788 VPWR VGND sg13g2_decap_8
XFILLER_7_612 VPWR VGND sg13g2_decap_8
XFILLER_11_685 VPWR VGND sg13g2_decap_8
XFILLER_7_689 VPWR VGND sg13g2_decap_8
XFILLER_6_199 VPWR VGND sg13g2_decap_8
XFILLER_3_862 VPWR VGND sg13g2_decap_8
XFILLER_2_361 VPWR VGND sg13g2_decap_8
XFILLER_33_7 VPWR VGND sg13g2_decap_4
X_2180_ net386 VPWR _0664_ VGND net257 _0663_ sg13g2_o21ai_1
XFILLER_38_516 VPWR VGND sg13g2_decap_8
XFILLER_34_711 VPWR VGND sg13g2_fill_1
XFILLER_46_593 VPWR VGND sg13g2_fill_1
XFILLER_46_582 VPWR VGND sg13g2_decap_8
XFILLER_22_906 VPWR VGND sg13g2_decap_8
X_1964_ _1307_ _0263_ _0486_ _0488_ VPWR VGND sg13g2_nor3_1
X_1895_ VGND VPWR _0372_ _0374_ _0421_ _0419_ sg13g2_a21oi_1
XFILLER_30_994 VPWR VGND sg13g2_decap_8
X_2516_ net395 VPWR _0910_ VGND net499 net298 sg13g2_o21ai_1
X_2447_ net380 falutop.i2c_inst.counter\[0\] falutop.i2c_inst.result\[7\] _0871_ VPWR
+ VGND sg13g2_nand3_1
X_2378_ _0710_ net408 _0825_ VPWR VGND sg13g2_nor2_2
XFILLER_17_14 VPWR VGND sg13g2_decap_8
XFILLER_29_538 VPWR VGND sg13g2_decap_8
XFILLER_24_243 VPWR VGND sg13g2_decap_4
XFILLER_25_777 VPWR VGND sg13g2_decap_8
XFILLER_40_725 VPWR VGND sg13g2_decap_8
XFILLER_24_276 VPWR VGND sg13g2_fill_1
XFILLER_25_799 VPWR VGND sg13g2_fill_1
XFILLER_3_158 VPWR VGND sg13g2_decap_8
XFILLER_0_854 VPWR VGND sg13g2_decap_8
Xhold9 _0115_ VPWR VGND net183 sg13g2_dlygate4sd3_1
XFILLER_48_847 VPWR VGND sg13g2_decap_8
XFILLER_35_519 VPWR VGND sg13g2_decap_4
XFILLER_31_703 VPWR VGND sg13g2_decap_8
XFILLER_31_769 VPWR VGND sg13g2_decap_8
XFILLER_12_983 VPWR VGND sg13g2_decap_8
XFILLER_8_943 VPWR VGND sg13g2_decap_8
X_1680_ _0186_ _0209_ _0210_ VPWR VGND sg13g2_nor2_1
XFILLER_48_1001 VPWR VGND sg13g2_decap_8
XFILLER_7_486 VPWR VGND sg13g2_decap_8
X_2301_ VGND VPWR net374 falutop.div_inst.a\[7\] _0762_ _0761_ sg13g2_a21oi_1
XFILLER_39_825 VPWR VGND sg13g2_decap_8
X_2232_ VPWR _0700_ net197 VGND sg13g2_inv_1
XFILLER_39_847 VPWR VGND sg13g2_fill_2
X_2163_ _0650_ VPWR _0126_ VGND net289 _0651_ sg13g2_o21ai_1
XFILLER_38_357 VPWR VGND sg13g2_decap_8
XFILLER_19_560 VPWR VGND sg13g2_decap_8
X_2094_ net490 falutop.alu_data_in\[3\] net288 _0100_ VPWR VGND sg13g2_mux2_1
XFILLER_19_593 VPWR VGND sg13g2_decap_8
XFILLER_9_81 VPWR VGND sg13g2_decap_4
X_1947_ _0472_ net371 _0432_ VPWR VGND sg13g2_nand2_1
X_1878_ _0404_ net316 net357 VPWR VGND sg13g2_nand2_2
XFILLER_44_316 VPWR VGND sg13g2_decap_8
XFILLER_40_511 VPWR VGND sg13g2_decap_8
XFILLER_25_585 VPWR VGND sg13g2_decap_8
XFILLER_12_224 VPWR VGND sg13g2_fill_1
XFILLER_40_588 VPWR VGND sg13g2_fill_1
XFILLER_8_206 VPWR VGND sg13g2_fill_1
XFILLER_5_924 VPWR VGND sg13g2_decap_8
XFILLER_5_39 VPWR VGND sg13g2_decap_8
XFILLER_4_467 VPWR VGND sg13g2_decap_8
XFILLER_0_651 VPWR VGND sg13g2_decap_8
XFILLER_48_644 VPWR VGND sg13g2_decap_4
XFILLER_47_154 VPWR VGND sg13g2_decap_8
XFILLER_29_880 VPWR VGND sg13g2_decap_4
XFILLER_31_511 VPWR VGND sg13g2_decap_8
XFILLER_43_382 VPWR VGND sg13g2_decap_8
X_2850_ net154 VGND VPWR _0071_ falutop.div_inst.rem\[0\] clknet_5_6__leaf_clk sg13g2_dfrbpq_2
X_1801_ _0327_ _0313_ _0329_ VPWR VGND sg13g2_xor2_1
XFILLER_31_577 VPWR VGND sg13g2_decap_8
XFILLER_8_740 VPWR VGND sg13g2_decap_8
X_2781_ net104 VGND VPWR net200 falutop.div_inst.quo\[3\] clknet_5_17__leaf_clk sg13g2_dfrbpq_1
XFILLER_12_780 VPWR VGND sg13g2_decap_8
X_1732_ net316 net365 _0261_ VPWR VGND sg13g2_and2_1
Xhold217 _0104_ VPWR VGND net518 sg13g2_dlygate4sd3_1
Xhold206 falutop.div_inst.val\[0\] VPWR VGND net507 sg13g2_dlygate4sd3_1
X_1663_ _0193_ _0192_ _0187_ VPWR VGND sg13g2_nand2b_1
X_1594_ _1292_ _1293_ _1282_ _1294_ VPWR VGND sg13g2_nand3_1
X_2215_ VGND VPWR net382 _0687_ _0141_ _0688_ sg13g2_a21oi_1
XFILLER_39_644 VPWR VGND sg13g2_decap_4
XFILLER_38_110 VPWR VGND sg13g2_decap_8
XFILLER_22_1004 VPWR VGND sg13g2_decap_8
XFILLER_26_327 VPWR VGND sg13g2_decap_8
X_2146_ _0637_ falutop.data_in\[2\] _0639_ VPWR VGND sg13g2_xor2_1
X_2077_ falutop.data_in\[11\] _0596_ _0597_ VPWR VGND sg13g2_nor2b_1
XFILLER_41_308 VPWR VGND sg13g2_decap_8
XFILLER_22_511 VPWR VGND sg13g2_fill_2
XFILLER_22_533 VPWR VGND sg13g2_fill_2
XFILLER_14_59 VPWR VGND sg13g2_fill_1
XFILLER_10_739 VPWR VGND sg13g2_decap_8
XFILLER_30_69 VPWR VGND sg13g2_fill_2
XFILLER_2_949 VPWR VGND sg13g2_decap_8
XFILLER_1_448 VPWR VGND sg13g2_decap_8
XFILLER_49_419 VPWR VGND sg13g2_decap_8
XFILLER_45_614 VPWR VGND sg13g2_decap_4
XFILLER_44_102 VPWR VGND sg13g2_decap_4
XFILLER_17_305 VPWR VGND sg13g2_fill_1
XFILLER_18_839 VPWR VGND sg13g2_decap_8
XFILLER_45_647 VPWR VGND sg13g2_decap_4
XFILLER_17_338 VPWR VGND sg13g2_fill_1
XFILLER_29_198 VPWR VGND sg13g2_decap_8
XFILLER_38_1022 VPWR VGND sg13g2_decap_8
X_2824__45 VPWR VGND net45 sg13g2_tiehi
XFILLER_41_886 VPWR VGND sg13g2_decap_8
XFILLER_9_526 VPWR VGND sg13g2_fill_2
XFILLER_13_555 VPWR VGND sg13g2_decap_8
XFILLER_13_588 VPWR VGND sg13g2_decap_8
XFILLER_5_721 VPWR VGND sg13g2_decap_8
XFILLER_4_231 VPWR VGND sg13g2_decap_8
X_2859__136 VPWR VGND net136 sg13g2_tiehi
XFILLER_5_798 VPWR VGND sg13g2_decap_8
XFILLER_45_1015 VPWR VGND sg13g2_decap_8
XFILLER_49_986 VPWR VGND sg13g2_decap_8
X_2000_ VGND VPWR _0523_ _0522_ _0521_ sg13g2_or2_1
XFILLER_48_496 VPWR VGND sg13g2_decap_4
XFILLER_17_872 VPWR VGND sg13g2_decap_8
XFILLER_17_883 VPWR VGND sg13g2_fill_1
X_2902_ net151 VGND VPWR net413 falutop.div_inst.b\[3\] clknet_5_9__leaf_clk sg13g2_dfrbpq_1
XFILLER_32_820 VPWR VGND sg13g2_decap_8
XFILLER_31_341 VPWR VGND sg13g2_decap_8
XFILLER_31_352 VPWR VGND sg13g2_fill_2
X_2833_ net32 VGND VPWR _0054_ falutop.div_inst.b1\[0\] clknet_5_6__leaf_clk sg13g2_dfrbpq_1
XFILLER_31_374 VPWR VGND sg13g2_decap_8
X_2764_ _1109_ _1123_ _1128_ _1150_ _1151_ VPWR VGND sg13g2_nor4_1
X_1715_ _0244_ _0239_ _0242_ VPWR VGND sg13g2_nand2_1
XFILLER_6_60 VPWR VGND sg13g2_decap_8
X_2695_ _1083_ net364 net344 net367 net339 VPWR VGND sg13g2_a22oi_1
X_1646_ _0176_ _0174_ _0175_ VPWR VGND sg13g2_nand2_1
X_1577_ _1277_ net361 net332 net364 net329 VPWR VGND sg13g2_a22oi_1
XFILLER_27_636 VPWR VGND sg13g2_decap_8
X_2129_ _0627_ falutop.data_in\[12\] _0626_ VPWR VGND sg13g2_xnor2_1
XFILLER_25_25 VPWR VGND sg13g2_decap_8
XFILLER_23_820 VPWR VGND sg13g2_fill_2
XFILLER_41_149 VPWR VGND sg13g2_decap_8
XFILLER_22_341 VPWR VGND sg13g2_fill_1
XFILLER_10_514 VPWR VGND sg13g2_decap_8
XFILLER_9_4 VPWR VGND sg13g2_decap_8
XFILLER_2_746 VPWR VGND sg13g2_decap_8
XFILLER_1_245 VPWR VGND sg13g2_decap_8
XFILLER_2_18 VPWR VGND sg13g2_decap_8
XFILLER_46_967 VPWR VGND sg13g2_decap_8
XFILLER_17_135 VPWR VGND sg13g2_fill_1
XFILLER_17_179 VPWR VGND sg13g2_fill_1
XFILLER_33_628 VPWR VGND sg13g2_decap_8
XFILLER_14_864 VPWR VGND sg13g2_decap_8
XFILLER_15_80 VPWR VGND sg13g2_decap_8
XFILLER_9_367 VPWR VGND sg13g2_fill_1
XFILLER_9_356 VPWR VGND sg13g2_decap_8
XFILLER_12_1025 VPWR VGND sg13g2_decap_4
X_2480_ net374 _0894_ net260 _0052_ VPWR VGND sg13g2_nor3_1
X_1500_ _1202_ _1195_ _1200_ VPWR VGND sg13g2_xnor2_1
XFILLER_5_595 VPWR VGND sg13g2_decap_8
XFILLER_49_783 VPWR VGND sg13g2_decap_8
XFILLER_37_956 VPWR VGND sg13g2_decap_8
XFILLER_36_433 VPWR VGND sg13g2_fill_1
XFILLER_17_680 VPWR VGND sg13g2_decap_4
XFILLER_32_672 VPWR VGND sg13g2_decap_8
X_2816_ net54 VGND VPWR net245 falutop.data_in\[9\] clknet_5_24__leaf_clk sg13g2_dfrbpq_2
X_2747_ _1084_ _1133_ _1134_ VPWR VGND sg13g2_nor2_1
X_2678_ _1066_ _1065_ _0994_ VPWR VGND sg13g2_nand2b_1
X_1629_ VPWR VGND _0918_ _1064_ _1080_ _0915_ _0160_ _1017_ sg13g2_a221oi_1
XFILLER_28_1010 VPWR VGND sg13g2_decap_8
Xfanout313 _0819_ net313 VPWR VGND sg13g2_buf_8
Xfanout302 _0887_ net302 VPWR VGND sg13g2_buf_8
Xfanout357 net360 net357 VPWR VGND sg13g2_buf_8
Xfanout346 net506 net346 VPWR VGND sg13g2_buf_8
Xfanout335 net336 net335 VPWR VGND sg13g2_buf_8
Xfanout324 net326 net324 VPWR VGND sg13g2_buf_2
Xfanout379 net435 net379 VPWR VGND sg13g2_buf_8
Xfanout368 falutop.alu_data_in\[0\] net368 VPWR VGND sg13g2_buf_8
XFILLER_28_912 VPWR VGND sg13g2_decap_8
XFILLER_42_403 VPWR VGND sg13g2_fill_2
XFILLER_27_455 VPWR VGND sg13g2_fill_1
XFILLER_28_989 VPWR VGND sg13g2_decap_8
XFILLER_43_948 VPWR VGND sg13g2_decap_8
XFILLER_14_116 VPWR VGND sg13g2_decap_8
XFILLER_14_127 VPWR VGND sg13g2_fill_1
XFILLER_23_683 VPWR VGND sg13g2_decap_8
XFILLER_35_1025 VPWR VGND sg13g2_decap_4
XFILLER_11_867 VPWR VGND sg13g2_decap_8
XFILLER_10_366 VPWR VGND sg13g2_decap_8
XFILLER_6_359 VPWR VGND sg13g2_decap_8
XFILLER_2_543 VPWR VGND sg13g2_decap_8
XFILLER_38_709 VPWR VGND sg13g2_decap_8
XFILLER_19_956 VPWR VGND sg13g2_decap_8
XFILLER_46_764 VPWR VGND sg13g2_decap_8
XFILLER_18_466 VPWR VGND sg13g2_decap_8
XFILLER_18_477 VPWR VGND sg13g2_fill_1
XFILLER_34_904 VPWR VGND sg13g2_decap_8
X_1980_ _0504_ _0503_ _0439_ VPWR VGND sg13g2_nand2b_1
XFILLER_26_90 VPWR VGND sg13g2_decap_8
XFILLER_33_447 VPWR VGND sg13g2_fill_1
XFILLER_14_661 VPWR VGND sg13g2_decap_8
X_2601_ _0720_ net323 _0989_ _0990_ VPWR VGND sg13g2_a21o_2
XFILLER_6_860 VPWR VGND sg13g2_decap_8
X_2532_ _0921_ net343 net368 VPWR VGND sg13g2_nand2_1
XFILLER_5_381 VPWR VGND sg13g2_decap_4
X_2463_ _0886_ net269 _0730_ net277 net406 VPWR VGND sg13g2_a22oi_1
X_2394_ _0840_ _0824_ net310 VPWR VGND sg13g2_nand2_2
XFILLER_49_580 VPWR VGND sg13g2_decap_8
XFILLER_37_731 VPWR VGND sg13g2_decap_4
XFILLER_3_1023 VPWR VGND sg13g2_decap_4
X_2875__95 VPWR VGND net95 sg13g2_tiehi
XFILLER_25_937 VPWR VGND sg13g2_decap_8
XFILLER_11_119 VPWR VGND sg13g2_decap_8
XFILLER_20_631 VPWR VGND sg13g2_decap_8
XFILLER_20_642 VPWR VGND sg13g2_fill_2
XFILLER_32_491 VPWR VGND sg13g2_decap_8
XFILLER_47_517 VPWR VGND sg13g2_decap_8
XFILLER_47_539 VPWR VGND sg13g2_decap_8
XFILLER_16_959 VPWR VGND sg13g2_decap_8
XFILLER_28_797 VPWR VGND sg13g2_fill_1
XFILLER_43_756 VPWR VGND sg13g2_decap_4
XFILLER_8_39 VPWR VGND sg13g2_decap_8
XFILLER_11_620 VPWR VGND sg13g2_decap_8
XFILLER_10_152 VPWR VGND sg13g2_decap_8
XFILLER_11_664 VPWR VGND sg13g2_fill_1
XFILLER_10_174 VPWR VGND sg13g2_decap_8
XFILLER_7_668 VPWR VGND sg13g2_decap_8
XFILLER_3_841 VPWR VGND sg13g2_decap_8
XFILLER_2_340 VPWR VGND sg13g2_decap_8
XFILLER_46_550 VPWR VGND sg13g2_fill_1
XFILLER_19_775 VPWR VGND sg13g2_fill_1
XFILLER_18_285 VPWR VGND sg13g2_decap_8
XFILLER_33_211 VPWR VGND sg13g2_fill_1
XFILLER_18_296 VPWR VGND sg13g2_fill_2
XFILLER_21_406 VPWR VGND sg13g2_decap_8
XFILLER_34_789 VPWR VGND sg13g2_decap_8
X_1963_ _1307_ _0486_ _0487_ VPWR VGND sg13g2_nor2_1
XFILLER_15_992 VPWR VGND sg13g2_decap_8
X_1894_ _0420_ _0372_ _0374_ _0419_ VPWR VGND sg13g2_and3_1
XFILLER_30_973 VPWR VGND sg13g2_decap_8
X_2515_ VGND VPWR _0797_ net299 _0073_ _0909_ sg13g2_a21oi_1
X_2446_ _0870_ falutop.i2c_inst.result\[6\] _0845_ VPWR VGND sg13g2_nand2_1
X_2377_ net176 falutop.i2c_inst.state\[0\] _0824_ VPWR VGND sg13g2_nor2b_2
XFILLER_29_517 VPWR VGND sg13g2_decap_8
XFILLER_37_550 VPWR VGND sg13g2_decap_8
XFILLER_37_594 VPWR VGND sg13g2_decap_8
XFILLER_37_572 VPWR VGND sg13g2_decap_8
XFILLER_13_929 VPWR VGND sg13g2_decap_8
XFILLER_40_759 VPWR VGND sg13g2_decap_4
XFILLER_32_1028 VPWR VGND sg13g2_fill_1
XFILLER_21_995 VPWR VGND sg13g2_decap_8
XFILLER_4_649 VPWR VGND sg13g2_decap_8
XFILLER_3_137 VPWR VGND sg13g2_decap_8
XFILLER_0_833 VPWR VGND sg13g2_decap_8
XFILLER_48_826 VPWR VGND sg13g2_decap_8
XFILLER_28_572 VPWR VGND sg13g2_decap_4
XFILLER_43_553 VPWR VGND sg13g2_decap_8
XFILLER_43_531 VPWR VGND sg13g2_decap_4
XFILLER_15_233 VPWR VGND sg13g2_decap_8
XFILLER_16_767 VPWR VGND sg13g2_decap_4
XFILLER_16_789 VPWR VGND sg13g2_decap_4
XFILLER_15_299 VPWR VGND sg13g2_decap_8
XFILLER_8_922 VPWR VGND sg13g2_decap_8
XFILLER_12_962 VPWR VGND sg13g2_decap_8
XFILLER_8_999 VPWR VGND sg13g2_decap_8
XFILLER_7_465 VPWR VGND sg13g2_decap_8
X_2300_ net374 net192 _0761_ VPWR VGND sg13g2_nor2b_1
X_2231_ VPWR _0699_ net3 VGND sg13g2_inv_1
XFILLER_24_4 VPWR VGND sg13g2_fill_2
XFILLER_38_336 VPWR VGND sg13g2_fill_1
X_2162_ _0649_ falutop.data_in\[6\] _0651_ VPWR VGND sg13g2_xor2_1
X_2093_ VGND VPWR _0726_ net286 _0099_ _0608_ sg13g2_a21oi_1
X_2869__116 VPWR VGND net116 sg13g2_tiehi
XFILLER_0_1015 VPWR VGND sg13g2_decap_8
XFILLER_0_84 VPWR VGND sg13g2_decap_8
XFILLER_34_520 VPWR VGND sg13g2_fill_1
XFILLER_22_715 VPWR VGND sg13g2_decap_8
XFILLER_34_564 VPWR VGND sg13g2_decap_8
XFILLER_34_586 VPWR VGND sg13g2_decap_8
XFILLER_21_225 VPWR VGND sg13g2_fill_1
XFILLER_22_748 VPWR VGND sg13g2_decap_8
XFILLER_9_60 VPWR VGND sg13g2_decap_8
XFILLER_21_269 VPWR VGND sg13g2_decap_8
X_1946_ net279 VPWR _0471_ VGND _0467_ _0470_ sg13g2_o21ai_1
X_1877_ _0403_ net330 net349 VPWR VGND sg13g2_nand2_1
X_2429_ net257 falutop.data_in\[3\] net311 _0031_ VPWR VGND sg13g2_mux2_1
XFILLER_29_336 VPWR VGND sg13g2_decap_8
XFILLER_29_347 VPWR VGND sg13g2_fill_2
XFILLER_44_328 VPWR VGND sg13g2_decap_4
XFILLER_13_715 VPWR VGND sg13g2_decap_8
XFILLER_25_564 VPWR VGND sg13g2_fill_2
XFILLER_40_545 VPWR VGND sg13g2_decap_8
XFILLER_9_719 VPWR VGND sg13g2_decap_8
XFILLER_12_269 VPWR VGND sg13g2_decap_8
XFILLER_21_770 VPWR VGND sg13g2_decap_8
XFILLER_5_903 VPWR VGND sg13g2_decap_8
Xclkbuf_5_16__f_clk clknet_4_8_0_clk clknet_5_16__leaf_clk VPWR VGND sg13g2_buf_8
XFILLER_5_18 VPWR VGND sg13g2_decap_8
XFILLER_4_446 VPWR VGND sg13g2_decap_8
XFILLER_0_630 VPWR VGND sg13g2_decap_8
XFILLER_47_100 VPWR VGND sg13g2_decap_8
XFILLER_48_656 VPWR VGND sg13g2_decap_8
XFILLER_47_133 VPWR VGND sg13g2_decap_4
XFILLER_29_892 VPWR VGND sg13g2_decap_8
XFILLER_43_350 VPWR VGND sg13g2_decap_4
XFILLER_44_895 VPWR VGND sg13g2_decap_8
XFILLER_16_586 VPWR VGND sg13g2_decap_8
X_1800_ _0328_ _0313_ _0327_ VPWR VGND sg13g2_nand2b_1
X_2780_ net105 VGND VPWR net196 falutop.div_inst.quo\[2\] clknet_5_20__leaf_clk sg13g2_dfrbpq_1
X_1731_ _0198_ VPWR _0260_ VGND _0196_ _0199_ sg13g2_o21ai_1
Xhold207 falutop.data_in\[11\] VPWR VGND net508 sg13g2_dlygate4sd3_1
XFILLER_8_796 VPWR VGND sg13g2_decap_8
XFILLER_7_273 VPWR VGND sg13g2_decap_8
X_1662_ _0190_ _0191_ _0192_ VPWR VGND sg13g2_nor2_1
Xhold218 falutop.data_in\[13\] VPWR VGND net519 sg13g2_dlygate4sd3_1
X_1593_ _1249_ VPWR _1293_ VGND _1289_ _1291_ sg13g2_o21ai_1
X_2214_ net387 VPWR _0688_ VGND net448 _0687_ sg13g2_o21ai_1
X_2145_ net268 net291 _0638_ VPWR VGND sg13g2_nor2_1
X_2076_ falutop.data_in\[8\] falutop.data_in\[9\] falutop.data_in\[10\] _0596_ VPWR
+ VGND sg13g2_nor3_1
XFILLER_19_380 VPWR VGND sg13g2_fill_2
XFILLER_10_718 VPWR VGND sg13g2_decap_8
X_1929_ _0454_ _0446_ _0452_ VPWR VGND sg13g2_xnor2_1
XFILLER_2_928 VPWR VGND sg13g2_decap_8
XFILLER_1_427 VPWR VGND sg13g2_decap_8
XFILLER_39_35 VPWR VGND sg13g2_fill_2
XFILLER_39_68 VPWR VGND sg13g2_fill_2
XFILLER_18_807 VPWR VGND sg13g2_decap_4
XFILLER_18_818 VPWR VGND sg13g2_decap_8
XFILLER_29_133 VPWR VGND sg13g2_fill_2
XFILLER_29_177 VPWR VGND sg13g2_decap_8
XFILLER_44_147 VPWR VGND sg13g2_decap_4
XFILLER_38_1001 VPWR VGND sg13g2_decap_8
XFILLER_13_534 VPWR VGND sg13g2_decap_8
XFILLER_41_865 VPWR VGND sg13g2_decap_8
XFILLER_40_342 VPWR VGND sg13g2_decap_8
XFILLER_9_505 VPWR VGND sg13g2_decap_8
XFILLER_5_700 VPWR VGND sg13g2_decap_8
XFILLER_5_777 VPWR VGND sg13g2_decap_8
XFILLER_4_287 VPWR VGND sg13g2_decap_8
XFILLER_20_81 VPWR VGND sg13g2_decap_8
XFILLER_1_994 VPWR VGND sg13g2_decap_8
XFILLER_49_965 VPWR VGND sg13g2_decap_8
Xhold90 falutop.i2c_inst.data_in\[17\] VPWR VGND net264 sg13g2_dlygate4sd3_1
XFILLER_36_604 VPWR VGND sg13g2_decap_8
XFILLER_35_114 VPWR VGND sg13g2_fill_2
XFILLER_35_136 VPWR VGND sg13g2_fill_2
XFILLER_16_383 VPWR VGND sg13g2_fill_1
XFILLER_16_394 VPWR VGND sg13g2_decap_8
X_2901_ net153 VGND VPWR net396 falutop.div_inst.b\[2\] clknet_5_9__leaf_clk sg13g2_dfrbpq_1
XFILLER_43_180 VPWR VGND sg13g2_fill_2
X_2830__38 VPWR VGND net38 sg13g2_tiehi
X_2832_ net34 VGND VPWR net202 falutop.div_inst.i\[2\] clknet_5_0__leaf_clk sg13g2_dfrbpq_1
X_2763_ _1139_ _1144_ _1137_ _1150_ VPWR VGND _1149_ sg13g2_nand4_1
X_1714_ _0239_ _0242_ _0243_ VPWR VGND sg13g2_nor2_1
XFILLER_8_593 VPWR VGND sg13g2_decap_8
X_2694_ _1030_ _1081_ _1082_ VPWR VGND sg13g2_nor2_1
X_1645_ net317 net333 _0173_ _0175_ VPWR VGND sg13g2_a21o_1
X_1576_ net329 net364 net332 _1276_ VPWR VGND net361 sg13g2_nand4_1
XFILLER_39_420 VPWR VGND sg13g2_fill_1
XFILLER_6_1021 VPWR VGND sg13g2_decap_8
XFILLER_27_615 VPWR VGND sg13g2_decap_8
X_2128_ _0597_ net370 _0626_ VPWR VGND sg13g2_nor2b_1
XFILLER_26_136 VPWR VGND sg13g2_decap_8
XFILLER_42_618 VPWR VGND sg13g2_decap_4
X_2059_ VGND VPWR _0579_ _0580_ _0581_ net295 sg13g2_a21oi_1
XFILLER_23_865 VPWR VGND sg13g2_fill_2
XFILLER_23_887 VPWR VGND sg13g2_decap_4
X_2821__49 VPWR VGND net49 sg13g2_tiehi
XFILLER_2_725 VPWR VGND sg13g2_decap_8
XFILLER_1_224 VPWR VGND sg13g2_decap_8
XFILLER_46_946 VPWR VGND sg13g2_decap_8
XFILLER_14_810 VPWR VGND sg13g2_decap_4
XFILLER_32_106 VPWR VGND sg13g2_fill_2
XFILLER_14_843 VPWR VGND sg13g2_decap_8
XFILLER_41_673 VPWR VGND sg13g2_decap_8
XFILLER_13_386 VPWR VGND sg13g2_decap_8
XFILLER_12_1004 VPWR VGND sg13g2_decap_8
XFILLER_5_574 VPWR VGND sg13g2_decap_8
XFILLER_1_791 VPWR VGND sg13g2_decap_8
XFILLER_49_762 VPWR VGND sg13g2_decap_8
XFILLER_37_935 VPWR VGND sg13g2_decap_8
XFILLER_20_813 VPWR VGND sg13g2_fill_1
XFILLER_20_868 VPWR VGND sg13g2_fill_2
X_2815_ net55 VGND VPWR _0036_ falutop.data_in\[8\] clknet_5_18__leaf_clk sg13g2_dfrbpq_2
X_2920__113 VPWR VGND net113 sg13g2_tiehi
XFILLER_9_880 VPWR VGND sg13g2_decap_8
X_2746_ _1131_ _1129_ _1133_ VPWR VGND sg13g2_xor2_1
X_2677_ _0990_ _1064_ net346 _1065_ VPWR VGND sg13g2_nand3_1
X_1628_ _1014_ _1008_ _0917_ _0159_ VPWR VGND sg13g2_mux2_1
Xfanout314 _0819_ net314 VPWR VGND sg13g2_buf_1
Xfanout303 _0860_ net303 VPWR VGND sg13g2_buf_8
Xfanout347 falutop.alu_data_in\[7\] net347 VPWR VGND sg13g2_buf_8
Xfanout325 net326 net325 VPWR VGND sg13g2_buf_8
Xfanout336 net337 net336 VPWR VGND sg13g2_buf_8
X_1559_ _1259_ _0937_ _1260_ VPWR VGND sg13g2_xor2_1
Xfanout369 falutop.alu_inst.op\[3\] net369 VPWR VGND sg13g2_buf_8
Xfanout358 net360 net358 VPWR VGND sg13g2_buf_8
XFILLER_27_434 VPWR VGND sg13g2_fill_1
XFILLER_28_968 VPWR VGND sg13g2_decap_8
XFILLER_43_927 VPWR VGND sg13g2_decap_8
XFILLER_15_618 VPWR VGND sg13g2_fill_2
XFILLER_42_437 VPWR VGND sg13g2_decap_4
XFILLER_36_990 VPWR VGND sg13g2_decap_8
XFILLER_14_139 VPWR VGND sg13g2_decap_8
XFILLER_23_651 VPWR VGND sg13g2_decap_8
XFILLER_35_1004 VPWR VGND sg13g2_decap_8
XFILLER_23_662 VPWR VGND sg13g2_fill_1
XFILLER_11_846 VPWR VGND sg13g2_decap_8
XFILLER_22_183 VPWR VGND sg13g2_fill_2
XFILLER_6_316 VPWR VGND sg13g2_decap_4
XFILLER_2_522 VPWR VGND sg13g2_decap_8
XFILLER_2_599 VPWR VGND sg13g2_decap_8
XFILLER_46_732 VPWR VGND sg13g2_fill_2
XFILLER_46_721 VPWR VGND sg13g2_decap_8
XFILLER_18_412 VPWR VGND sg13g2_fill_1
XFILLER_19_935 VPWR VGND sg13g2_decap_8
XFILLER_45_297 VPWR VGND sg13g2_fill_1
XFILLER_33_437 VPWR VGND sg13g2_fill_1
XFILLER_42_982 VPWR VGND sg13g2_decap_8
XFILLER_9_198 VPWR VGND sg13g2_decap_8
X_2600_ _0989_ _0988_ net315 VPWR VGND sg13g2_nand2b_1
X_2531_ net344 net367 _0920_ VPWR VGND sg13g2_and2_1
X_2462_ _0885_ _0884_ _0044_ VPWR VGND sg13g2_nor2b_1
X_2393_ net381 _0826_ _0839_ VPWR VGND sg13g2_nor2_1
XFILLER_3_1002 VPWR VGND sg13g2_decap_8
XFILLER_3_95 VPWR VGND sg13g2_decap_8
XFILLER_25_916 VPWR VGND sg13g2_decap_8
XFILLER_37_798 VPWR VGND sg13g2_decap_8
XFILLER_36_286 VPWR VGND sg13g2_decap_4
XFILLER_40_919 VPWR VGND sg13g2_decap_8
XFILLER_20_621 VPWR VGND sg13g2_decap_4
X_2796__81 VPWR VGND net81 sg13g2_tiehi
X_2729_ _1116_ _1114_ _1115_ VPWR VGND sg13g2_nand2_1
XFILLER_19_209 VPWR VGND sg13g2_decap_8
XFILLER_28_710 VPWR VGND sg13g2_decap_8
XFILLER_28_732 VPWR VGND sg13g2_decap_4
XFILLER_28_765 VPWR VGND sg13g2_decap_8
XFILLER_43_713 VPWR VGND sg13g2_fill_2
XFILLER_16_938 VPWR VGND sg13g2_decap_8
XFILLER_28_787 VPWR VGND sg13g2_fill_1
X_2881__77 VPWR VGND net77 sg13g2_tiehi
XFILLER_42_256 VPWR VGND sg13g2_fill_1
XFILLER_24_982 VPWR VGND sg13g2_decap_8
XFILLER_30_418 VPWR VGND sg13g2_fill_1
XFILLER_8_18 VPWR VGND sg13g2_decap_8
XFILLER_23_470 VPWR VGND sg13g2_decap_8
XFILLER_10_131 VPWR VGND sg13g2_decap_8
XFILLER_11_643 VPWR VGND sg13g2_decap_8
XFILLER_7_647 VPWR VGND sg13g2_decap_8
XFILLER_3_820 VPWR VGND sg13g2_decap_8
XFILLER_12_82 VPWR VGND sg13g2_decap_4
XFILLER_3_897 VPWR VGND sg13g2_decap_8
XFILLER_2_396 VPWR VGND sg13g2_decap_8
XFILLER_34_702 VPWR VGND sg13g2_decap_8
XFILLER_18_264 VPWR VGND sg13g2_decap_8
XFILLER_34_746 VPWR VGND sg13g2_fill_2
XFILLER_15_971 VPWR VGND sg13g2_decap_8
XFILLER_18_1010 VPWR VGND sg13g2_decap_8
XFILLER_33_256 VPWR VGND sg13g2_fill_2
XFILLER_34_779 VPWR VGND sg13g2_fill_2
XFILLER_14_481 VPWR VGND sg13g2_decap_8
X_1962_ net316 VPWR _0486_ VGND net356 net352 sg13g2_o21ai_1
X_1893_ _0419_ _0392_ _0417_ VPWR VGND sg13g2_xnor2_1
XFILLER_30_952 VPWR VGND sg13g2_decap_8
XFILLER_45_0 VPWR VGND sg13g2_decap_4
X_2514_ net385 VPWR _0909_ VGND net494 net299 sg13g2_o21ai_1
X_2445_ _0867_ _0868_ _0866_ _0869_ VPWR VGND sg13g2_nand3_1
XFILLER_25_1014 VPWR VGND sg13g2_decap_8
X_2376_ net176 _0714_ _0823_ _0020_ VPWR VGND sg13g2_nor3_1
XFILLER_17_49 VPWR VGND sg13g2_decap_8
XFILLER_13_908 VPWR VGND sg13g2_decap_8
XFILLER_24_212 VPWR VGND sg13g2_decap_8
XFILLER_33_15 VPWR VGND sg13g2_decap_8
XFILLER_33_59 VPWR VGND sg13g2_decap_8
XFILLER_33_790 VPWR VGND sg13g2_decap_8
XFILLER_20_451 VPWR VGND sg13g2_fill_2
XFILLER_21_974 VPWR VGND sg13g2_decap_8
XFILLER_32_1007 VPWR VGND sg13g2_decap_8
XFILLER_4_628 VPWR VGND sg13g2_decap_8
XFILLER_3_116 VPWR VGND sg13g2_decap_8
XFILLER_0_812 VPWR VGND sg13g2_decap_8
XFILLER_48_805 VPWR VGND sg13g2_decap_8
XFILLER_47_304 VPWR VGND sg13g2_decap_8
XFILLER_0_889 VPWR VGND sg13g2_decap_8
XFILLER_47_359 VPWR VGND sg13g2_decap_4
XFILLER_43_510 VPWR VGND sg13g2_fill_2
XFILLER_16_724 VPWR VGND sg13g2_decap_4
XFILLER_28_584 VPWR VGND sg13g2_decap_8
XFILLER_15_212 VPWR VGND sg13g2_decap_8
XFILLER_15_267 VPWR VGND sg13g2_decap_8
XFILLER_43_598 VPWR VGND sg13g2_decap_8
XFILLER_12_941 VPWR VGND sg13g2_decap_8
XFILLER_8_901 VPWR VGND sg13g2_decap_8
XFILLER_11_440 VPWR VGND sg13g2_decap_4
XFILLER_11_473 VPWR VGND sg13g2_decap_8
XFILLER_8_978 VPWR VGND sg13g2_decap_8
XFILLER_7_444 VPWR VGND sg13g2_decap_8
X_2230_ VGND VPWR net384 _0697_ _0146_ _0698_ sg13g2_a21oi_1
XFILLER_3_694 VPWR VGND sg13g2_decap_8
XFILLER_2_193 VPWR VGND sg13g2_decap_8
XFILLER_39_849 VPWR VGND sg13g2_fill_1
X_2161_ _0650_ net222 net289 VPWR VGND sg13g2_nand2_1
X_2092_ net523 net288 _0608_ VPWR VGND sg13g2_nor2_2
XFILLER_47_882 VPWR VGND sg13g2_decap_8
XFILLER_0_63 VPWR VGND sg13g2_decap_8
XFILLER_21_248 VPWR VGND sg13g2_fill_1
X_1945_ _0339_ VPWR _0470_ VGND _0468_ _0469_ sg13g2_o21ai_1
X_1876_ VGND VPWR _0201_ _0364_ _0402_ _0363_ sg13g2_a21oi_1
XFILLER_1_609 VPWR VGND sg13g2_decap_8
XFILLER_0_119 VPWR VGND sg13g2_decap_8
X_2428_ net404 falutop.data_in\[2\] net311 _0030_ VPWR VGND sg13g2_mux2_1
X_2359_ _0812_ VPWR _0813_ VGND net266 net269 sg13g2_o21ai_1
XFILLER_28_15 VPWR VGND sg13g2_fill_1
XFILLER_28_48 VPWR VGND sg13g2_decap_8
XFILLER_29_315 VPWR VGND sg13g2_decap_8
XFILLER_45_819 VPWR VGND sg13g2_decap_8
XFILLER_38_882 VPWR VGND sg13g2_decap_8
XFILLER_37_392 VPWR VGND sg13g2_decap_8
XFILLER_40_535 VPWR VGND sg13g2_fill_1
XFILLER_13_749 VPWR VGND sg13g2_fill_2
XFILLER_40_579 VPWR VGND sg13g2_decap_8
XFILLER_12_248 VPWR VGND sg13g2_decap_8
XFILLER_4_425 VPWR VGND sg13g2_decap_8
XFILLER_5_959 VPWR VGND sg13g2_decap_8
X_2900__155 VPWR VGND net155 sg13g2_tiehi
XFILLER_0_686 VPWR VGND sg13g2_decap_8
XFILLER_47_123 VPWR VGND sg13g2_fill_1
XFILLER_44_874 VPWR VGND sg13g2_decap_8
XFILLER_16_565 VPWR VGND sg13g2_decap_8
XFILLER_15_1013 VPWR VGND sg13g2_decap_8
XFILLER_12_760 VPWR VGND sg13g2_fill_1
X_1730_ VGND VPWR _0195_ _0208_ _0259_ _0207_ sg13g2_a21oi_1
XFILLER_8_775 VPWR VGND sg13g2_decap_8
X_1661_ _0191_ net362 net331 net365 net325 VPWR VGND sg13g2_a22oi_1
Xhold208 _0108_ VPWR VGND net509 sg13g2_dlygate4sd3_1
Xhold219 _0110_ VPWR VGND net520 sg13g2_dlygate4sd3_1
X_1592_ _1249_ _1289_ _1291_ _1292_ VPWR VGND sg13g2_or3_1
XFILLER_4_992 VPWR VGND sg13g2_decap_8
XFILLER_3_491 VPWR VGND sg13g2_decap_8
XFILLER_39_602 VPWR VGND sg13g2_decap_8
X_2213_ _0657_ _0684_ _0687_ VPWR VGND sg13g2_nor2_1
XFILLER_27_808 VPWR VGND sg13g2_decap_8
X_2144_ net373 VPWR _0637_ VGND net207 falutop.data_in\[1\] sg13g2_o21ai_1
XFILLER_26_318 VPWR VGND sg13g2_decap_4
X_2075_ VGND VPWR _0591_ _0594_ _0094_ _0595_ sg13g2_a21oi_1
Xclkbuf_5_22__f_clk clknet_4_11_0_clk clknet_5_22__leaf_clk VPWR VGND sg13g2_buf_8
XFILLER_34_340 VPWR VGND sg13g2_decap_8
XFILLER_35_852 VPWR VGND sg13g2_decap_8
XFILLER_35_863 VPWR VGND sg13g2_fill_2
XFILLER_35_885 VPWR VGND sg13g2_decap_8
XFILLER_22_513 VPWR VGND sg13g2_fill_1
XFILLER_22_535 VPWR VGND sg13g2_fill_1
XFILLER_34_384 VPWR VGND sg13g2_fill_1
X_1928_ _0453_ _0446_ _0452_ VPWR VGND sg13g2_nand2_1
XFILLER_30_16 VPWR VGND sg13g2_decap_8
X_1859_ _0386_ net282 _0385_ VPWR VGND sg13g2_nand2_1
XFILLER_2_907 VPWR VGND sg13g2_decap_8
XFILLER_1_406 VPWR VGND sg13g2_decap_8
XFILLER_29_123 VPWR VGND sg13g2_fill_1
XFILLER_44_126 VPWR VGND sg13g2_decap_8
XFILLER_26_852 VPWR VGND sg13g2_decap_4
XFILLER_41_844 VPWR VGND sg13g2_decap_8
XFILLER_26_896 VPWR VGND sg13g2_fill_1
XFILLER_40_321 VPWR VGND sg13g2_decap_8
XFILLER_5_756 VPWR VGND sg13g2_decap_8
XFILLER_20_60 VPWR VGND sg13g2_decap_8
XFILLER_49_944 VPWR VGND sg13g2_decap_8
XFILLER_1_973 VPWR VGND sg13g2_decap_8
XFILLER_0_483 VPWR VGND sg13g2_decap_8
Xhold91 _0017_ VPWR VGND net265 sg13g2_dlygate4sd3_1
Xhold80 falutop.data_in\[8\] VPWR VGND net254 sg13g2_dlygate4sd3_1
XFILLER_36_627 VPWR VGND sg13g2_decap_8
XFILLER_16_362 VPWR VGND sg13g2_decap_8
XFILLER_17_896 VPWR VGND sg13g2_decap_8
X_2900_ net155 VGND VPWR net243 falutop.div_inst.b\[1\] clknet_5_3__leaf_clk sg13g2_dfrbpq_1
XFILLER_32_833 VPWR VGND sg13g2_decap_4
X_2907__139 VPWR VGND net139 sg13g2_tiehi
X_2831_ net36 VGND VPWR net261 falutop.div_inst.i\[1\] clknet_5_1__leaf_clk sg13g2_dfrbpq_1
XFILLER_32_888 VPWR VGND sg13g2_decap_8
X_2762_ VGND VPWR _1088_ _1141_ _1149_ _1148_ sg13g2_a21oi_1
XFILLER_8_572 VPWR VGND sg13g2_decap_8
X_1713_ _0242_ net347 _0240_ VPWR VGND sg13g2_xnor2_1
X_2693_ VGND VPWR _0982_ _0984_ _1081_ _0983_ sg13g2_a21oi_1
X_1644_ net316 _0173_ net333 _0174_ VPWR VGND sg13g2_nand3_1
X_1575_ net332 net329 net364 net361 _1275_ VPWR VGND sg13g2_and4_1
XFILLER_6_1000 VPWR VGND sg13g2_decap_8
XFILLER_39_454 VPWR VGND sg13g2_decap_8
X_2127_ net205 net292 _0625_ VPWR VGND sg13g2_nor2_1
X_2058_ VGND VPWR falutop.div_inst.rem\[6\] _0578_ _0580_ net303 sg13g2_a21oi_1
XFILLER_41_107 VPWR VGND sg13g2_decap_8
XFILLER_22_332 VPWR VGND sg13g2_decap_8
XFILLER_23_844 VPWR VGND sg13g2_decap_8
XFILLER_22_376 VPWR VGND sg13g2_fill_1
XFILLER_2_704 VPWR VGND sg13g2_decap_8
XFILLER_1_203 VPWR VGND sg13g2_decap_8
XFILLER_49_229 VPWR VGND sg13g2_decap_8
XFILLER_46_925 VPWR VGND sg13g2_decap_8
XFILLER_17_126 VPWR VGND sg13g2_decap_8
XFILLER_18_649 VPWR VGND sg13g2_decap_8
XFILLER_45_457 VPWR VGND sg13g2_fill_2
XFILLER_41_652 VPWR VGND sg13g2_decap_4
XFILLER_13_332 VPWR VGND sg13g2_decap_4
XFILLER_14_899 VPWR VGND sg13g2_decap_8
X_2820__50 VPWR VGND net50 sg13g2_tiehi
XFILLER_5_553 VPWR VGND sg13g2_decap_8
XFILLER_31_81 VPWR VGND sg13g2_decap_4
XFILLER_49_7 VPWR VGND sg13g2_decap_8
XFILLER_1_770 VPWR VGND sg13g2_decap_8
XFILLER_49_741 VPWR VGND sg13g2_decap_8
XFILLER_0_280 VPWR VGND sg13g2_decap_8
XFILLER_48_240 VPWR VGND sg13g2_fill_2
XFILLER_37_914 VPWR VGND sg13g2_decap_8
XFILLER_36_424 VPWR VGND sg13g2_fill_2
XFILLER_45_980 VPWR VGND sg13g2_decap_8
XFILLER_23_107 VPWR VGND sg13g2_fill_2
XFILLER_32_641 VPWR VGND sg13g2_decap_8
XFILLER_20_825 VPWR VGND sg13g2_decap_8
X_2814_ net56 VGND VPWR net411 falutop.data_in\[7\] clknet_5_9__leaf_clk sg13g2_dfrbpq_2
XFILLER_31_162 VPWR VGND sg13g2_fill_2
XFILLER_11_18 VPWR VGND sg13g2_decap_8
X_2745_ _1132_ _1131_ _1129_ VPWR VGND sg13g2_nand2b_1
X_2676_ _0985_ _0993_ _1064_ VPWR VGND sg13g2_nor2b_2
X_1627_ _0158_ _0918_ _0970_ VPWR VGND sg13g2_xnor2_1
Xfanout304 net306 net304 VPWR VGND sg13g2_buf_8
Xfanout315 net318 net315 VPWR VGND sg13g2_buf_8
Xfanout348 falutop.alu_data_in\[7\] net348 VPWR VGND sg13g2_buf_2
Xfanout337 falutop.alu_data_in\[10\] net337 VPWR VGND sg13g2_buf_8
Xfanout326 falutop.alu_data_in\[13\] net326 VPWR VGND sg13g2_buf_8
X_1558_ _1174_ _0925_ _0924_ _1259_ VPWR VGND sg13g2_a21o_1
X_1489_ _1173_ _1190_ _1191_ VPWR VGND sg13g2_nor2_1
Xfanout359 net360 net359 VPWR VGND sg13g2_buf_1
XFILLER_28_947 VPWR VGND sg13g2_decap_8
XFILLER_43_906 VPWR VGND sg13g2_decap_8
XFILLER_11_825 VPWR VGND sg13g2_decap_8
XFILLER_22_140 VPWR VGND sg13g2_decap_8
XFILLER_22_151 VPWR VGND sg13g2_fill_2
XFILLER_10_313 VPWR VGND sg13g2_decap_8
XFILLER_7_829 VPWR VGND sg13g2_decap_8
X_2802__72 VPWR VGND net72 sg13g2_tiehi
XFILLER_2_501 VPWR VGND sg13g2_decap_8
XFILLER_2_578 VPWR VGND sg13g2_decap_8
XFILLER_46_700 VPWR VGND sg13g2_decap_8
XFILLER_19_914 VPWR VGND sg13g2_decap_8
XFILLER_18_435 VPWR VGND sg13g2_fill_1
XFILLER_45_254 VPWR VGND sg13g2_fill_2
XFILLER_46_799 VPWR VGND sg13g2_decap_8
XFILLER_33_427 VPWR VGND sg13g2_fill_1
XFILLER_34_939 VPWR VGND sg13g2_decap_8
XFILLER_42_961 VPWR VGND sg13g2_decap_8
XFILLER_14_652 VPWR VGND sg13g2_decap_4
XFILLER_9_177 VPWR VGND sg13g2_decap_8
X_2530_ _0919_ _0916_ _0917_ VPWR VGND sg13g2_nand2_2
X_2461_ net386 VPWR _0885_ VGND net496 _0825_ sg13g2_o21ai_1
XFILLER_6_895 VPWR VGND sg13g2_decap_8
X_2392_ VPWR VGND net408 _0838_ _0836_ _0710_ _0021_ _0832_ sg13g2_a221oi_1
XFILLER_3_74 VPWR VGND sg13g2_decap_8
XFILLER_36_210 VPWR VGND sg13g2_fill_2
XFILLER_37_777 VPWR VGND sg13g2_decap_8
XFILLER_33_994 VPWR VGND sg13g2_decap_8
XFILLER_3_309 VPWR VGND sg13g2_decap_8
X_2728_ net321 net344 net361 _1115_ VPWR VGND sg13g2_a21o_1
X_2659_ VGND VPWR falutop.div_inst.val\[0\] net307 _1047_ falutop.div_inst.val\[1\]
+ sg13g2_a21oi_1
XFILLER_47_14 VPWR VGND sg13g2_decap_8
XFILLER_47_69 VPWR VGND sg13g2_decap_8
XFILLER_16_917 VPWR VGND sg13g2_decap_8
XFILLER_43_736 VPWR VGND sg13g2_fill_1
XFILLER_27_298 VPWR VGND sg13g2_decap_4
XFILLER_42_279 VPWR VGND sg13g2_decap_8
XFILLER_42_268 VPWR VGND sg13g2_fill_1
XFILLER_24_961 VPWR VGND sg13g2_decap_8
XFILLER_23_493 VPWR VGND sg13g2_decap_8
XFILLER_7_626 VPWR VGND sg13g2_decap_8
XFILLER_11_699 VPWR VGND sg13g2_decap_8
XFILLER_3_876 VPWR VGND sg13g2_decap_8
XFILLER_2_375 VPWR VGND sg13g2_decap_8
XFILLER_19_722 VPWR VGND sg13g2_fill_2
XFILLER_46_541 VPWR VGND sg13g2_decap_8
Xclkbuf_5_3__f_clk clknet_4_1_0_clk clknet_5_3__leaf_clk VPWR VGND sg13g2_buf_8
XFILLER_46_563 VPWR VGND sg13g2_decap_4
XFILLER_34_769 VPWR VGND sg13g2_fill_1
XFILLER_15_950 VPWR VGND sg13g2_decap_8
X_1961_ _0453_ VPWR _0485_ VGND _0445_ _0454_ sg13g2_o21ai_1
XFILLER_30_931 VPWR VGND sg13g2_decap_8
X_1892_ _0392_ _0417_ _0418_ VPWR VGND sg13g2_and2_1
X_2513_ VGND VPWR _0793_ net298 _0072_ _0908_ sg13g2_a21oi_1
XFILLER_6_692 VPWR VGND sg13g2_decap_8
XFILLER_5_180 VPWR VGND sg13g2_decap_8
X_2444_ VPWR VGND falutop.i2c_inst.result\[2\] falutop.i2c_inst.counter\[2\] _0845_
+ falutop.i2c_inst.result\[0\] _0868_ net310 sg13g2_a221oi_1
X_2375_ VGND VPWR net1 _0727_ _0823_ falutop.i2c_inst.state\[0\] sg13g2_a21oi_1
XFILLER_38_0 VPWR VGND sg13g2_decap_8
XFILLER_17_28 VPWR VGND sg13g2_decap_8
XFILLER_25_736 VPWR VGND sg13g2_decap_8
XFILLER_40_706 VPWR VGND sg13g2_decap_4
XFILLER_20_430 VPWR VGND sg13g2_decap_4
XFILLER_21_953 VPWR VGND sg13g2_decap_8
XFILLER_20_463 VPWR VGND sg13g2_decap_8
XFILLER_4_607 VPWR VGND sg13g2_decap_8
XFILLER_20_496 VPWR VGND sg13g2_decap_8
XFILLER_0_868 VPWR VGND sg13g2_decap_8
XFILLER_28_530 VPWR VGND sg13g2_fill_1
XFILLER_16_703 VPWR VGND sg13g2_decap_8
XFILLER_31_717 VPWR VGND sg13g2_decap_8
XFILLER_12_920 VPWR VGND sg13g2_decap_8
XFILLER_31_728 VPWR VGND sg13g2_fill_1
XFILLER_11_430 VPWR VGND sg13g2_decap_4
XFILLER_30_238 VPWR VGND sg13g2_decap_8
XFILLER_8_957 VPWR VGND sg13g2_decap_8
XFILLER_7_423 VPWR VGND sg13g2_fill_2
XFILLER_12_997 VPWR VGND sg13g2_decap_8
XFILLER_23_71 VPWR VGND sg13g2_decap_4
XFILLER_23_82 VPWR VGND sg13g2_decap_8
XFILLER_48_1015 VPWR VGND sg13g2_decap_8
XFILLER_3_673 VPWR VGND sg13g2_decap_8
XFILLER_2_172 VPWR VGND sg13g2_decap_8
XFILLER_39_839 VPWR VGND sg13g2_fill_2
X_2160_ _0649_ net373 _0605_ VPWR VGND sg13g2_nand2_1
X_2091_ falutop.data_in\[1\] net497 net288 _0098_ VPWR VGND sg13g2_mux2_1
XFILLER_47_861 VPWR VGND sg13g2_decap_8
XFILLER_0_42 VPWR VGND sg13g2_decap_8
XFILLER_19_574 VPWR VGND sg13g2_fill_2
XFILLER_34_544 VPWR VGND sg13g2_fill_1
XFILLER_34_555 VPWR VGND sg13g2_decap_4
X_1944_ net282 VPWR _0469_ VGND net334 net272 sg13g2_o21ai_1
XFILLER_30_772 VPWR VGND sg13g2_fill_2
X_1875_ _0401_ _0263_ _0399_ VPWR VGND sg13g2_xnor2_1
XFILLER_7_990 VPWR VGND sg13g2_decap_8
X_2427_ net246 falutop.data_in\[1\] net311 _0029_ VPWR VGND sg13g2_mux2_1
XFILLER_9_1020 VPWR VGND sg13g2_decap_8
Xclkbuf_4_15_0_clk clknet_0_clk clknet_4_15_0_clk VPWR VGND sg13g2_buf_8
X_2358_ _0812_ net269 _0811_ VPWR VGND sg13g2_nand2_1
XFILLER_28_27 VPWR VGND sg13g2_decap_8
X_2289_ VGND VPWR net377 falutop.div_inst.a\[4\] _0753_ _0752_ sg13g2_a21oi_1
XFILLER_25_500 VPWR VGND sg13g2_decap_8
XFILLER_44_26 VPWR VGND sg13g2_fill_1
XFILLER_44_15 VPWR VGND sg13g2_decap_8
XFILLER_25_599 VPWR VGND sg13g2_decap_8
XFILLER_21_761 VPWR VGND sg13g2_fill_1
XFILLER_5_938 VPWR VGND sg13g2_decap_8
XFILLER_4_404 VPWR VGND sg13g2_decap_8
XFILLER_48_603 VPWR VGND sg13g2_decap_8
XFILLER_0_665 VPWR VGND sg13g2_decap_8
XFILLER_48_625 VPWR VGND sg13g2_decap_4
XFILLER_47_179 VPWR VGND sg13g2_decap_8
XFILLER_47_168 VPWR VGND sg13g2_decap_8
XFILLER_35_308 VPWR VGND sg13g2_decap_8
XFILLER_16_533 VPWR VGND sg13g2_decap_8
XFILLER_28_382 VPWR VGND sg13g2_decap_8
XFILLER_44_853 VPWR VGND sg13g2_decap_8
XFILLER_16_544 VPWR VGND sg13g2_fill_1
XFILLER_31_536 VPWR VGND sg13g2_decap_8
XFILLER_43_396 VPWR VGND sg13g2_decap_8
XFILLER_34_92 VPWR VGND sg13g2_fill_1
XFILLER_8_754 VPWR VGND sg13g2_decap_8
XFILLER_7_220 VPWR VGND sg13g2_decap_4
XFILLER_12_794 VPWR VGND sg13g2_decap_8
XFILLER_7_253 VPWR VGND sg13g2_decap_8
X_1660_ VPWR _0190_ _0189_ VGND sg13g2_inv_1
Xhold209 falutop.data_in\[9\] VPWR VGND net510 sg13g2_dlygate4sd3_1
X_1591_ _1291_ _1287_ _1288_ net358 net335 VPWR VGND sg13g2_a22oi_1
XFILLER_4_971 VPWR VGND sg13g2_decap_8
XFILLER_3_470 VPWR VGND sg13g2_decap_8
X_2212_ VGND VPWR net383 _0685_ _0140_ _0686_ sg13g2_a21oi_1
XFILLER_39_669 VPWR VGND sg13g2_decap_8
XFILLER_38_135 VPWR VGND sg13g2_fill_2
XFILLER_22_1018 VPWR VGND sg13g2_decap_8
X_2143_ VGND VPWR net292 _0636_ _0121_ _0634_ sg13g2_a21oi_1
XFILLER_38_157 VPWR VGND sg13g2_decap_8
X_2074_ net392 VPWR _0595_ VGND net465 _0862_ sg13g2_o21ai_1
XFILLER_35_831 VPWR VGND sg13g2_fill_2
XFILLER_14_18 VPWR VGND sg13g2_decap_4
X_1927_ _0452_ _0447_ _0451_ VPWR VGND sg13g2_xnor2_1
X_1858_ net338 net366 net272 _0385_ VPWR VGND sg13g2_mux2_1
X_1789_ _0317_ _0263_ _0316_ VPWR VGND sg13g2_xnor2_1
XFILLER_39_37 VPWR VGND sg13g2_fill_1
XFILLER_29_135 VPWR VGND sg13g2_fill_1
XFILLER_26_820 VPWR VGND sg13g2_decap_8
XFILLER_40_300 VPWR VGND sg13g2_decap_8
XFILLER_25_374 VPWR VGND sg13g2_decap_8
XFILLER_25_385 VPWR VGND sg13g2_fill_2
XFILLER_13_569 VPWR VGND sg13g2_decap_8
XFILLER_40_388 VPWR VGND sg13g2_decap_8
XFILLER_5_735 VPWR VGND sg13g2_decap_8
XFILLER_4_245 VPWR VGND sg13g2_decap_8
XFILLER_1_952 VPWR VGND sg13g2_decap_8
XFILLER_49_923 VPWR VGND sg13g2_decap_8
XFILLER_0_462 VPWR VGND sg13g2_decap_8
Xhold81 falutop.i2c_inst.data_in\[10\] VPWR VGND net255 sg13g2_dlygate4sd3_1
Xhold92 falutop.div_inst.acc\[6\] VPWR VGND net266 sg13g2_dlygate4sd3_1
XFILLER_29_92 VPWR VGND sg13g2_decap_8
Xhold70 falutop.i2c_inst.data_in\[9\] VPWR VGND net244 sg13g2_dlygate4sd3_1
XFILLER_35_138 VPWR VGND sg13g2_fill_1
XFILLER_36_639 VPWR VGND sg13g2_decap_8
XFILLER_44_672 VPWR VGND sg13g2_fill_2
X_2830_ net38 VGND VPWR net234 falutop.div_inst.i\[0\] clknet_5_1__leaf_clk sg13g2_dfrbpq_1
X_2761_ _1143_ _1147_ _1136_ _1148_ VPWR VGND sg13g2_nand3_1
XFILLER_31_388 VPWR VGND sg13g2_decap_8
XFILLER_8_551 VPWR VGND sg13g2_decap_8
X_2692_ falutop.alu_inst.op\[2\] _1005_ _1080_ VPWR VGND sg13g2_and2_1
X_1712_ net348 _0240_ _0241_ VPWR VGND sg13g2_and2_1
X_1643_ _0173_ net350 _0172_ VPWR VGND sg13g2_xnor2_1
XFILLER_6_74 VPWR VGND sg13g2_decap_8
X_1574_ _1252_ _1244_ _1251_ _1274_ VPWR VGND sg13g2_a21o_1
XFILLER_27_606 VPWR VGND sg13g2_decap_4
X_2126_ VGND VPWR net292 _0624_ _0116_ _0622_ sg13g2_a21oi_1
X_2057_ VGND VPWR _0579_ _0578_ falutop.div_inst.rem\[6\] sg13g2_or2_1
XFILLER_23_834 VPWR VGND sg13g2_fill_2
XFILLER_25_39 VPWR VGND sg13g2_decap_4
XFILLER_22_322 VPWR VGND sg13g2_decap_4
XFILLER_23_867 VPWR VGND sg13g2_fill_1
XFILLER_41_27 VPWR VGND sg13g2_decap_8
XFILLER_41_16 VPWR VGND sg13g2_fill_2
XFILLER_10_528 VPWR VGND sg13g2_decap_8
XFILLER_1_259 VPWR VGND sg13g2_decap_8
XFILLER_46_904 VPWR VGND sg13g2_decap_8
XFILLER_26_672 VPWR VGND sg13g2_decap_8
XFILLER_32_108 VPWR VGND sg13g2_fill_1
XFILLER_32_119 VPWR VGND sg13g2_decap_4
XFILLER_41_631 VPWR VGND sg13g2_decap_8
XFILLER_25_182 VPWR VGND sg13g2_fill_2
XFILLER_9_315 VPWR VGND sg13g2_fill_2
XFILLER_9_304 VPWR VGND sg13g2_decap_8
XFILLER_14_878 VPWR VGND sg13g2_decap_8
XFILLER_15_94 VPWR VGND sg13g2_decap_8
XFILLER_5_532 VPWR VGND sg13g2_decap_8
XFILLER_31_60 VPWR VGND sg13g2_decap_8
XFILLER_49_720 VPWR VGND sg13g2_decap_8
XFILLER_49_797 VPWR VGND sg13g2_decap_8
XFILLER_17_650 VPWR VGND sg13g2_decap_8
XFILLER_36_447 VPWR VGND sg13g2_decap_8
XFILLER_16_160 VPWR VGND sg13g2_fill_1
XFILLER_17_661 VPWR VGND sg13g2_fill_1
XFILLER_44_480 VPWR VGND sg13g2_fill_2
XFILLER_20_804 VPWR VGND sg13g2_decap_8
XFILLER_31_130 VPWR VGND sg13g2_fill_2
XFILLER_31_152 VPWR VGND sg13g2_decap_4
X_2813_ net57 VGND VPWR net424 falutop.data_in\[6\] clknet_5_10__leaf_clk sg13g2_dfrbpq_2
XFILLER_32_686 VPWR VGND sg13g2_decap_8
X_2744_ _1131_ net308 _1113_ VPWR VGND sg13g2_xnor2_1
XFILLER_8_392 VPWR VGND sg13g2_decap_8
X_2675_ _0716_ _1062_ _1063_ VPWR VGND sg13g2_nor2_1
X_1626_ _0157_ _0918_ _0155_ VPWR VGND sg13g2_xnor2_1
X_1557_ _0969_ _0937_ _1258_ VPWR VGND sg13g2_xor2_1
Xfanout305 net306 net305 VPWR VGND sg13g2_buf_1
XFILLER_28_1024 VPWR VGND sg13g2_decap_4
Xfanout338 net342 net338 VPWR VGND sg13g2_buf_8
Xfanout327 net331 net327 VPWR VGND sg13g2_buf_8
Xfanout316 net317 net316 VPWR VGND sg13g2_buf_8
X_1488_ VGND VPWR _1187_ _1188_ _1190_ _1189_ sg13g2_a21oi_1
Xfanout349 net350 net349 VPWR VGND sg13g2_buf_8
XFILLER_39_241 VPWR VGND sg13g2_fill_1
XFILLER_28_926 VPWR VGND sg13g2_decap_8
XFILLER_39_274 VPWR VGND sg13g2_decap_8
XFILLER_27_414 VPWR VGND sg13g2_fill_2
XFILLER_27_425 VPWR VGND sg13g2_decap_8
X_2109_ net519 net287 _0614_ VPWR VGND sg13g2_nor2_1
XFILLER_35_491 VPWR VGND sg13g2_decap_8
XFILLER_11_804 VPWR VGND sg13g2_decap_8
XFILLER_23_675 VPWR VGND sg13g2_fill_2
XFILLER_23_697 VPWR VGND sg13g2_fill_1
XFILLER_7_808 VPWR VGND sg13g2_decap_8
XFILLER_6_329 VPWR VGND sg13g2_fill_2
XFILLER_2_557 VPWR VGND sg13g2_decap_8
XFILLER_46_778 VPWR VGND sg13g2_decap_8
XFILLER_34_918 VPWR VGND sg13g2_decap_8
XFILLER_27_981 VPWR VGND sg13g2_decap_8
XFILLER_42_940 VPWR VGND sg13g2_decap_8
XFILLER_13_130 VPWR VGND sg13g2_decap_8
XFILLER_14_675 VPWR VGND sg13g2_fill_2
XFILLER_14_697 VPWR VGND sg13g2_fill_2
X_2460_ _0874_ _0883_ _0825_ _0884_ VPWR VGND sg13g2_nand3_1
XFILLER_6_874 VPWR VGND sg13g2_decap_8
X_2391_ _0838_ net387 _0837_ VPWR VGND sg13g2_nand2_1
XFILLER_3_53 VPWR VGND sg13g2_decap_8
XFILLER_49_594 VPWR VGND sg13g2_decap_8
XFILLER_37_756 VPWR VGND sg13g2_fill_2
XFILLER_24_406 VPWR VGND sg13g2_decap_4
XFILLER_17_480 VPWR VGND sg13g2_decap_8
XFILLER_33_973 VPWR VGND sg13g2_decap_8
XFILLER_22_18 VPWR VGND sg13g2_decap_8
X_2727_ net321 net361 net344 _1114_ VPWR VGND sg13g2_nand3_1
X_2658_ falutop.div_inst.val\[0\] net307 falutop.div_inst.val\[1\] _1046_ VPWR VGND
+ sg13g2_nand3_1
X_2589_ _0978_ _0722_ net369 VPWR VGND sg13g2_nand2_2
X_1609_ _1308_ VPWR _1309_ VGND net351 _1216_ sg13g2_o21ai_1
XFILLER_27_211 VPWR VGND sg13g2_decap_8
XFILLER_27_233 VPWR VGND sg13g2_decap_8
XFILLER_43_715 VPWR VGND sg13g2_fill_1
XFILLER_27_255 VPWR VGND sg13g2_decap_8
XFILLER_42_236 VPWR VGND sg13g2_fill_1
XFILLER_24_940 VPWR VGND sg13g2_decap_8
XFILLER_7_605 VPWR VGND sg13g2_decap_8
XFILLER_11_634 VPWR VGND sg13g2_fill_2
XFILLER_11_678 VPWR VGND sg13g2_decap_8
XFILLER_12_51 VPWR VGND sg13g2_decap_8
XFILLER_12_62 VPWR VGND sg13g2_fill_2
XFILLER_3_855 VPWR VGND sg13g2_decap_8
XFILLER_2_354 VPWR VGND sg13g2_decap_8
XFILLER_46_520 VPWR VGND sg13g2_decap_8
XFILLER_18_211 VPWR VGND sg13g2_decap_8
XFILLER_18_233 VPWR VGND sg13g2_fill_2
XFILLER_19_745 VPWR VGND sg13g2_fill_2
X_1960_ _0484_ _0349_ _0482_ VPWR VGND sg13g2_xnor2_1
XFILLER_42_781 VPWR VGND sg13g2_decap_8
XFILLER_30_910 VPWR VGND sg13g2_decap_8
X_1891_ _0415_ _0393_ _0417_ VPWR VGND sg13g2_xor2_1
XFILLER_30_987 VPWR VGND sg13g2_decap_8
XFILLER_6_671 VPWR VGND sg13g2_decap_8
X_2793__86 VPWR VGND net86 sg13g2_tiehi
X_2512_ net385 VPWR _0908_ VGND net492 net298 sg13g2_o21ai_1
X_2443_ net380 net381 falutop.i2c_inst.result\[3\] _0867_ VPWR VGND sg13g2_nand3_1
X_2374_ VGND VPWR _0712_ net314 _0019_ _0822_ sg13g2_a21oi_1
XFILLER_37_564 VPWR VGND sg13g2_fill_2
XFILLER_37_586 VPWR VGND sg13g2_fill_2
XFILLER_24_236 VPWR VGND sg13g2_decap_8
XFILLER_24_247 VPWR VGND sg13g2_fill_2
XFILLER_24_269 VPWR VGND sg13g2_decap_8
XFILLER_21_932 VPWR VGND sg13g2_decap_8
XFILLER_0_847 VPWR VGND sg13g2_decap_8
XFILLER_28_597 VPWR VGND sg13g2_decap_8
XFILLER_43_567 VPWR VGND sg13g2_fill_2
XFILLER_15_247 VPWR VGND sg13g2_decap_4
XFILLER_23_280 VPWR VGND sg13g2_decap_8
XFILLER_8_936 VPWR VGND sg13g2_decap_8
XFILLER_7_402 VPWR VGND sg13g2_decap_8
XFILLER_12_976 VPWR VGND sg13g2_decap_8
XFILLER_7_479 VPWR VGND sg13g2_decap_8
XFILLER_3_652 VPWR VGND sg13g2_decap_8
XFILLER_2_151 VPWR VGND sg13g2_decap_8
XFILLER_39_818 VPWR VGND sg13g2_decap_8
XFILLER_47_840 VPWR VGND sg13g2_decap_8
XFILLER_19_542 VPWR VGND sg13g2_decap_4
X_2090_ net207 net500 net288 _0097_ VPWR VGND sg13g2_mux2_1
XFILLER_0_21 VPWR VGND sg13g2_decap_8
XFILLER_46_383 VPWR VGND sg13g2_fill_2
XFILLER_46_372 VPWR VGND sg13g2_decap_8
XFILLER_19_586 VPWR VGND sg13g2_decap_8
XFILLER_0_98 VPWR VGND sg13g2_decap_8
XFILLER_21_217 VPWR VGND sg13g2_fill_1
XFILLER_22_729 VPWR VGND sg13g2_fill_2
XFILLER_34_578 VPWR VGND sg13g2_fill_2
XFILLER_30_740 VPWR VGND sg13g2_decap_8
X_1943_ net357 _0976_ _0468_ VPWR VGND sg13g2_nor2_1
XFILLER_9_85 VPWR VGND sg13g2_fill_2
XFILLER_9_74 VPWR VGND sg13g2_decap_8
XFILLER_30_751 VPWR VGND sg13g2_fill_2
X_1874_ _0400_ _0262_ _0399_ VPWR VGND sg13g2_nand2_1
X_2426_ _0865_ VPWR _0028_ VGND _0700_ net311 sg13g2_o21ai_1
X_2357_ _0811_ _0782_ _0783_ VPWR VGND sg13g2_xnor2_1
X_2288_ _0703_ net377 _0752_ VPWR VGND sg13g2_nor2_1
XFILLER_44_309 VPWR VGND sg13g2_decap_8
XFILLER_37_383 VPWR VGND sg13g2_fill_1
XFILLER_37_372 VPWR VGND sg13g2_decap_8
XFILLER_25_534 VPWR VGND sg13g2_decap_8
XFILLER_40_504 VPWR VGND sg13g2_decap_8
XFILLER_13_729 VPWR VGND sg13g2_fill_1
XFILLER_25_578 VPWR VGND sg13g2_decap_8
XFILLER_40_559 VPWR VGND sg13g2_decap_8
XFILLER_21_740 VPWR VGND sg13g2_decap_8
XFILLER_20_261 VPWR VGND sg13g2_fill_1
XFILLER_20_272 VPWR VGND sg13g2_fill_2
XFILLER_21_784 VPWR VGND sg13g2_decap_4
XFILLER_5_917 VPWR VGND sg13g2_decap_8
XFILLER_0_644 VPWR VGND sg13g2_decap_8
XFILLER_29_840 VPWR VGND sg13g2_decap_4
XFILLER_47_147 VPWR VGND sg13g2_decap_8
XFILLER_29_873 VPWR VGND sg13g2_decap_8
XFILLER_44_832 VPWR VGND sg13g2_decap_8
XFILLER_16_523 VPWR VGND sg13g2_decap_4
XFILLER_43_320 VPWR VGND sg13g2_fill_2
XFILLER_31_526 VPWR VGND sg13g2_fill_1
XFILLER_34_71 VPWR VGND sg13g2_fill_1
XFILLER_11_250 VPWR VGND sg13g2_fill_2
XFILLER_12_773 VPWR VGND sg13g2_decap_8
XFILLER_8_733 VPWR VGND sg13g2_decap_8
XFILLER_7_287 VPWR VGND sg13g2_fill_1
X_1590_ net358 _1287_ net335 _1290_ VPWR VGND _1288_ sg13g2_nand4_1
XFILLER_4_950 VPWR VGND sg13g2_decap_8
X_2211_ net387 VPWR _0686_ VGND net421 _0685_ sg13g2_o21ai_1
XFILLER_38_103 VPWR VGND sg13g2_decap_8
XFILLER_22_4 VPWR VGND sg13g2_decap_8
XFILLER_39_637 VPWR VGND sg13g2_decap_8
X_2142_ _0635_ falutop.data_in\[1\] _0636_ VPWR VGND sg13g2_xor2_1
X_2073_ VGND VPWR net304 _0593_ _0594_ net295 sg13g2_a21oi_1
XFILLER_47_681 VPWR VGND sg13g2_fill_1
XFILLER_22_504 VPWR VGND sg13g2_decap_8
XFILLER_22_526 VPWR VGND sg13g2_decap_8
X_1926_ _0451_ _0404_ _0448_ VPWR VGND sg13g2_xnor2_1
X_1857_ _0379_ _0336_ _0383_ _0384_ VPWR VGND sg13g2_a21o_2
X_1788_ _0314_ _0315_ _0316_ VPWR VGND sg13g2_nor2_1
X_2409_ _0827_ VPWR _0852_ VGND _0826_ _0851_ sg13g2_o21ai_1
XFILLER_29_103 VPWR VGND sg13g2_fill_2
XFILLER_45_618 VPWR VGND sg13g2_fill_2
XFILLER_45_607 VPWR VGND sg13g2_decap_8
XFILLER_44_106 VPWR VGND sg13g2_fill_2
XFILLER_38_670 VPWR VGND sg13g2_decap_8
XFILLER_41_824 VPWR VGND sg13g2_fill_2
XFILLER_41_802 VPWR VGND sg13g2_fill_2
XFILLER_38_1015 VPWR VGND sg13g2_decap_8
XFILLER_13_548 VPWR VGND sg13g2_decap_8
XFILLER_41_879 VPWR VGND sg13g2_decap_8
XFILLER_9_519 VPWR VGND sg13g2_decap_8
XFILLER_21_592 VPWR VGND sg13g2_fill_2
XFILLER_5_714 VPWR VGND sg13g2_decap_8
XFILLER_4_224 VPWR VGND sg13g2_decap_8
XFILLER_45_1008 VPWR VGND sg13g2_decap_8
XFILLER_1_931 VPWR VGND sg13g2_decap_8
XFILLER_49_902 VPWR VGND sg13g2_decap_8
XFILLER_0_441 VPWR VGND sg13g2_decap_8
XFILLER_29_71 VPWR VGND sg13g2_decap_8
XFILLER_49_979 VPWR VGND sg13g2_decap_8
XFILLER_48_467 VPWR VGND sg13g2_fill_2
Xhold82 _0038_ VPWR VGND net256 sg13g2_dlygate4sd3_1
Xhold60 _0051_ VPWR VGND net234 sg13g2_dlygate4sd3_1
Xhold71 _0037_ VPWR VGND net245 sg13g2_dlygate4sd3_1
XFILLER_36_618 VPWR VGND sg13g2_decap_4
XFILLER_17_810 VPWR VGND sg13g2_decap_8
Xhold93 _0013_ VPWR VGND net267 sg13g2_dlygate4sd3_1
XFILLER_44_651 VPWR VGND sg13g2_decap_8
XFILLER_16_342 VPWR VGND sg13g2_decap_8
XFILLER_17_865 VPWR VGND sg13g2_decap_8
XFILLER_32_813 VPWR VGND sg13g2_decap_8
XFILLER_44_695 VPWR VGND sg13g2_decap_8
XFILLER_31_323 VPWR VGND sg13g2_decap_4
XFILLER_32_868 VPWR VGND sg13g2_decap_4
Xclkbuf_4_14_0_clk clknet_0_clk clknet_4_14_0_clk VPWR VGND sg13g2_buf_8
XFILLER_8_530 VPWR VGND sg13g2_fill_2
X_2760_ VPWR VGND _0929_ _1146_ _1080_ _0926_ _1147_ _1017_ sg13g2_a221oi_1
X_2691_ _1077_ _0999_ _1079_ VPWR VGND sg13g2_xor2_1
X_1711_ _0174_ VPWR _0240_ VGND _0725_ _0172_ sg13g2_o21ai_1
X_1642_ VGND VPWR net341 _1307_ _0172_ _1311_ sg13g2_a21oi_1
XFILLER_6_53 VPWR VGND sg13g2_decap_8
X_1573_ _0714_ _1269_ _1273_ _0083_ VPWR VGND sg13g2_nor3_1
X_2125_ _0624_ falutop.data_in\[11\] _0623_ VPWR VGND sg13g2_xnor2_1
XFILLER_27_629 VPWR VGND sg13g2_decap_8
X_2056_ _0578_ _0552_ _0553_ VPWR VGND sg13g2_nand2_1
XFILLER_25_18 VPWR VGND sg13g2_decap_8
XFILLER_23_802 VPWR VGND sg13g2_decap_8
XFILLER_35_673 VPWR VGND sg13g2_fill_2
XFILLER_22_356 VPWR VGND sg13g2_fill_2
X_1909_ net392 VPWR _0435_ VGND net482 _0862_ sg13g2_o21ai_1
X_2889_ net44 VGND VPWR net520 falutop.alu_data_in\[13\] clknet_5_21__leaf_clk sg13g2_dfrbpq_1
XFILLER_2_739 VPWR VGND sg13g2_decap_8
XFILLER_1_238 VPWR VGND sg13g2_decap_8
XFILLER_26_640 VPWR VGND sg13g2_decap_8
XFILLER_41_610 VPWR VGND sg13g2_decap_8
XFILLER_14_857 VPWR VGND sg13g2_decap_8
XFILLER_9_349 VPWR VGND sg13g2_decap_8
XFILLER_12_1018 VPWR VGND sg13g2_decap_8
XFILLER_5_511 VPWR VGND sg13g2_decap_8
XFILLER_5_588 VPWR VGND sg13g2_decap_8
Xoutput4 net4 uo_out[0] VPWR VGND sg13g2_buf_1
XFILLER_49_776 VPWR VGND sg13g2_decap_8
XFILLER_48_242 VPWR VGND sg13g2_fill_1
XFILLER_37_949 VPWR VGND sg13g2_decap_8
XFILLER_17_684 VPWR VGND sg13g2_fill_2
XFILLER_16_194 VPWR VGND sg13g2_decap_8
X_2812_ net58 VGND VPWR net446 falutop.data_in\[5\] clknet_5_10__leaf_clk sg13g2_dfrbpq_2
X_2743_ VGND VPWR _1130_ _1113_ _0931_ sg13g2_or2_1
XFILLER_8_382 VPWR VGND sg13g2_decap_4
XFILLER_9_894 VPWR VGND sg13g2_decap_8
X_2674_ _1062_ net274 _0993_ VPWR VGND sg13g2_nand2_1
X_1625_ _0919_ _0155_ _0156_ VPWR VGND sg13g2_nor2_1
X_1556_ _1255_ _1236_ _1257_ VPWR VGND sg13g2_xor2_1
XFILLER_28_1003 VPWR VGND sg13g2_decap_8
Xfanout306 _0859_ net306 VPWR VGND sg13g2_buf_8
Xfanout328 net331 net328 VPWR VGND sg13g2_buf_1
Xfanout339 net341 net339 VPWR VGND sg13g2_buf_8
Xfanout317 net318 net317 VPWR VGND sg13g2_buf_8
X_1487_ VPWR VGND _1070_ _0994_ _1064_ _0985_ _1189_ _1063_ sg13g2_a221oi_1
X_2108_ net502 net327 net287 _0109_ VPWR VGND sg13g2_mux2_1
XFILLER_27_448 VPWR VGND sg13g2_decap_8
XFILLER_14_109 VPWR VGND sg13g2_fill_1
X_2039_ _0489_ _0560_ _0561_ VPWR VGND sg13g2_nor2_1
XFILLER_23_621 VPWR VGND sg13g2_fill_1
XFILLER_35_1018 VPWR VGND sg13g2_decap_8
XFILLER_2_536 VPWR VGND sg13g2_decap_8
XFILLER_19_949 VPWR VGND sg13g2_decap_8
XFILLER_46_757 VPWR VGND sg13g2_decap_8
XFILLER_27_960 VPWR VGND sg13g2_decap_8
XFILLER_26_83 VPWR VGND sg13g2_decap_8
XFILLER_42_996 VPWR VGND sg13g2_decap_8
XFILLER_6_853 VPWR VGND sg13g2_decap_8
XFILLER_10_893 VPWR VGND sg13g2_decap_8
X_2390_ net310 _0834_ net176 _0837_ VPWR VGND sg13g2_nand3_1
XFILLER_3_32 VPWR VGND sg13g2_decap_8
XFILLER_49_573 VPWR VGND sg13g2_decap_8
XFILLER_37_713 VPWR VGND sg13g2_decap_4
XFILLER_3_1027 VPWR VGND sg13g2_fill_2
XFILLER_3_1016 VPWR VGND sg13g2_decap_8
XFILLER_37_735 VPWR VGND sg13g2_fill_1
XFILLER_36_212 VPWR VGND sg13g2_fill_1
XFILLER_18_982 VPWR VGND sg13g2_decap_8
XFILLER_33_952 VPWR VGND sg13g2_decap_8
XFILLER_32_473 VPWR VGND sg13g2_decap_4
XFILLER_9_691 VPWR VGND sg13g2_decap_8
X_2726_ _1113_ net344 net361 VPWR VGND sg13g2_nand2_1
X_2657_ net371 falutop.data_in\[7\] _1045_ VPWR VGND sg13g2_xor2_1
X_1608_ _1308_ net341 _1307_ VPWR VGND sg13g2_nand2_1
X_2588_ _0977_ _0721_ falutop.alu_inst.op\[1\] VPWR VGND sg13g2_nand2_2
Xclkbuf_5_28__f_clk clknet_4_14_0_clk clknet_5_28__leaf_clk VPWR VGND sg13g2_buf_8
X_1539_ _1240_ _0927_ _1238_ VPWR VGND sg13g2_nand2_1
XFILLER_15_418 VPWR VGND sg13g2_decap_4
XFILLER_43_749 VPWR VGND sg13g2_decap_8
XFILLER_42_204 VPWR VGND sg13g2_decap_4
XFILLER_10_101 VPWR VGND sg13g2_decap_4
XFILLER_11_613 VPWR VGND sg13g2_decap_8
XFILLER_24_996 VPWR VGND sg13g2_decap_8
XFILLER_11_657 VPWR VGND sg13g2_decap_8
XFILLER_10_145 VPWR VGND sg13g2_decap_8
XFILLER_12_96 VPWR VGND sg13g2_fill_2
XFILLER_3_834 VPWR VGND sg13g2_decap_8
XFILLER_2_333 VPWR VGND sg13g2_decap_8
Xhold190 _0100_ VPWR VGND net491 sg13g2_dlygate4sd3_1
XFILLER_19_724 VPWR VGND sg13g2_fill_1
XFILLER_19_768 VPWR VGND sg13g2_decap_8
XFILLER_18_278 VPWR VGND sg13g2_decap_8
XFILLER_33_204 VPWR VGND sg13g2_decap_8
XFILLER_15_985 VPWR VGND sg13g2_decap_8
XFILLER_18_1024 VPWR VGND sg13g2_decap_4
X_1890_ _0393_ _0415_ _0416_ VPWR VGND sg13g2_nor2_1
XFILLER_14_495 VPWR VGND sg13g2_decap_8
XFILLER_30_966 VPWR VGND sg13g2_decap_8
XFILLER_10_690 VPWR VGND sg13g2_decap_8
XFILLER_6_650 VPWR VGND sg13g2_decap_8
X_2511_ VGND VPWR _0789_ net300 _0071_ _0907_ sg13g2_a21oi_1
X_2442_ _0866_ falutop.i2c_inst.result\[1\] _0846_ VPWR VGND sg13g2_nand2_1
X_2373_ net218 net314 _0822_ VPWR VGND sg13g2_nor2_1
XFILLER_25_1028 VPWR VGND sg13g2_fill_1
XFILLER_24_226 VPWR VGND sg13g2_decap_4
XFILLER_21_911 VPWR VGND sg13g2_decap_8
XFILLER_33_771 VPWR VGND sg13g2_decap_8
XFILLER_21_988 VPWR VGND sg13g2_decap_8
X_2709_ _1094_ _1095_ _1092_ _1097_ VPWR VGND _1096_ sg13g2_nand4_1
XFILLER_0_826 VPWR VGND sg13g2_decap_8
XFILLER_48_819 VPWR VGND sg13g2_decap_8
XFILLER_28_565 VPWR VGND sg13g2_decap_8
XFILLER_28_576 VPWR VGND sg13g2_fill_2
XFILLER_43_535 VPWR VGND sg13g2_fill_1
XFILLER_43_524 VPWR VGND sg13g2_decap_8
XFILLER_15_226 VPWR VGND sg13g2_decap_8
XFILLER_43_546 VPWR VGND sg13g2_decap_8
XFILLER_12_955 VPWR VGND sg13g2_decap_8
XFILLER_8_915 VPWR VGND sg13g2_decap_8
XFILLER_7_458 VPWR VGND sg13g2_decap_8
XFILLER_7_425 VPWR VGND sg13g2_fill_1
XFILLER_11_487 VPWR VGND sg13g2_fill_2
XFILLER_3_631 VPWR VGND sg13g2_decap_8
XFILLER_2_130 VPWR VGND sg13g2_decap_8
Xclkbuf_5_11__f_clk clknet_4_5_0_clk clknet_5_11__leaf_clk VPWR VGND sg13g2_buf_8
XFILLER_48_92 VPWR VGND sg13g2_decap_4
XFILLER_17_7 VPWR VGND sg13g2_decap_8
XFILLER_46_351 VPWR VGND sg13g2_fill_2
XFILLER_0_1008 VPWR VGND sg13g2_decap_8
XFILLER_47_896 VPWR VGND sg13g2_decap_8
XFILLER_0_77 VPWR VGND sg13g2_decap_8
XFILLER_46_395 VPWR VGND sg13g2_decap_8
XFILLER_22_708 VPWR VGND sg13g2_decap_8
XFILLER_21_207 VPWR VGND sg13g2_fill_1
XFILLER_9_53 VPWR VGND sg13g2_decap_8
X_2845__164 VPWR VGND net164 sg13g2_tiehi
XFILLER_15_793 VPWR VGND sg13g2_fill_1
X_1942_ _1019_ _0466_ _0467_ VPWR VGND sg13g2_nor2_1
XFILLER_30_774 VPWR VGND sg13g2_fill_1
X_1873_ _0399_ _0915_ _0398_ VPWR VGND sg13g2_xnor2_1
XFILLER_43_0 VPWR VGND sg13g2_decap_8
X_2425_ _0865_ net207 net311 VPWR VGND sg13g2_nand2_1
X_2356_ _0810_ net228 net277 VPWR VGND sg13g2_nand2_1
XFILLER_38_841 VPWR VGND sg13g2_fill_2
X_2287_ VGND VPWR net276 _0750_ _0003_ _0751_ sg13g2_a21oi_1
XFILLER_29_329 VPWR VGND sg13g2_decap_8
XFILLER_38_863 VPWR VGND sg13g2_fill_2
XFILLER_37_351 VPWR VGND sg13g2_decap_8
XFILLER_38_896 VPWR VGND sg13g2_decap_8
XFILLER_13_708 VPWR VGND sg13g2_decap_8
XFILLER_25_557 VPWR VGND sg13g2_decap_8
XFILLER_4_439 VPWR VGND sg13g2_decap_8
XFILLER_0_623 VPWR VGND sg13g2_decap_8
XFILLER_47_137 VPWR VGND sg13g2_fill_1
XFILLER_44_811 VPWR VGND sg13g2_decap_8
XFILLER_44_888 VPWR VGND sg13g2_decap_8
XFILLER_16_579 VPWR VGND sg13g2_decap_8
XFILLER_8_712 VPWR VGND sg13g2_decap_8
XFILLER_15_1027 VPWR VGND sg13g2_fill_2
XFILLER_7_200 VPWR VGND sg13g2_decap_4
XFILLER_11_273 VPWR VGND sg13g2_fill_2
XFILLER_11_284 VPWR VGND sg13g2_decap_8
XFILLER_8_789 VPWR VGND sg13g2_decap_8
XFILLER_7_266 VPWR VGND sg13g2_decap_8
X_2210_ _0840_ _0684_ _0685_ VPWR VGND sg13g2_nor2_1
XFILLER_39_616 VPWR VGND sg13g2_decap_4
X_2141_ _0635_ net373 net207 VPWR VGND sg13g2_nand2_1
X_2072_ _0593_ falutop.div_inst.rem\[7\] _0592_ VPWR VGND sg13g2_xnor2_1
XFILLER_47_693 VPWR VGND sg13g2_decap_8
XFILLER_47_671 VPWR VGND sg13g2_decap_4
XFILLER_19_362 VPWR VGND sg13g2_decap_8
XFILLER_19_351 VPWR VGND sg13g2_decap_4
XFILLER_35_833 VPWR VGND sg13g2_fill_1
XFILLER_46_181 VPWR VGND sg13g2_decap_4
XFILLER_19_395 VPWR VGND sg13g2_decap_8
XFILLER_34_354 VPWR VGND sg13g2_decap_8
XFILLER_35_899 VPWR VGND sg13g2_decap_8
X_1925_ VGND VPWR net316 net357 _0450_ _0448_ sg13g2_a21oi_1
X_1856_ _0383_ _0381_ _0382_ VPWR VGND sg13g2_nand2_1
X_1787_ _0315_ net351 net333 net356 net329 VPWR VGND sg13g2_a22oi_1
X_2408_ _0851_ _0829_ net436 VPWR VGND sg13g2_nand2b_1
X_2339_ _0796_ VPWR _0797_ VGND net224 net270 sg13g2_o21ai_1
XFILLER_41_858 VPWR VGND sg13g2_decap_8
XFILLER_40_335 VPWR VGND sg13g2_decap_8
XFILLER_13_527 VPWR VGND sg13g2_decap_8
XFILLER_21_560 VPWR VGND sg13g2_decap_8
XFILLER_1_910 VPWR VGND sg13g2_decap_8
XFILLER_20_74 VPWR VGND sg13g2_decap_8
XFILLER_0_420 VPWR VGND sg13g2_decap_8
XFILLER_1_987 VPWR VGND sg13g2_decap_8
XFILLER_49_958 VPWR VGND sg13g2_decap_8
XFILLER_48_424 VPWR VGND sg13g2_decap_8
XFILLER_0_497 VPWR VGND sg13g2_decap_8
Xhold50 falutop.div_inst.acc\[2\] VPWR VGND net224 sg13g2_dlygate4sd3_1
Xhold83 falutop.i2c_inst.data_in\[3\] VPWR VGND net257 sg13g2_dlygate4sd3_1
Xhold72 falutop.i2c_inst.data_in\[1\] VPWR VGND net246 sg13g2_dlygate4sd3_1
Xhold61 falutop.div_inst.val\[3\] VPWR VGND net235 sg13g2_dlygate4sd3_1
Xhold94 falutop.div_inst.b\[2\] VPWR VGND net268 sg13g2_dlygate4sd3_1
XFILLER_35_129 VPWR VGND sg13g2_decap_8
XFILLER_44_630 VPWR VGND sg13g2_decap_8
XFILLER_16_321 VPWR VGND sg13g2_decap_8
XFILLER_17_833 VPWR VGND sg13g2_fill_2
XFILLER_44_674 VPWR VGND sg13g2_fill_1
XFILLER_43_151 VPWR VGND sg13g2_decap_8
XFILLER_16_376 VPWR VGND sg13g2_decap_8
XFILLER_31_302 VPWR VGND sg13g2_decap_8
XFILLER_40_891 VPWR VGND sg13g2_decap_8
X_2690_ _0999_ _1077_ _1078_ VPWR VGND sg13g2_nor2_1
X_1710_ _0178_ _0181_ _0239_ VPWR VGND sg13g2_nor2_1
XFILLER_8_586 VPWR VGND sg13g2_decap_8
XFILLER_6_32 VPWR VGND sg13g2_decap_8
X_1641_ _0170_ _0171_ _0084_ VPWR VGND sg13g2_nor2_1
X_1572_ _1272_ VPWR _1273_ VGND net481 net293 sg13g2_o21ai_1
Xclkbuf_5_9__f_clk clknet_4_4_0_clk clknet_5_9__leaf_clk VPWR VGND sg13g2_buf_8
XFILLER_6_1014 VPWR VGND sg13g2_decap_8
X_2124_ _0596_ net370 _0623_ VPWR VGND sg13g2_nor2b_1
XFILLER_48_980 VPWR VGND sg13g2_decap_8
XFILLER_19_170 VPWR VGND sg13g2_decap_4
X_2055_ net279 VPWR _0577_ VGND _0573_ _0576_ sg13g2_o21ai_1
XFILLER_35_641 VPWR VGND sg13g2_decap_8
XFILLER_22_302 VPWR VGND sg13g2_fill_2
XFILLER_23_858 VPWR VGND sg13g2_decap_8
XFILLER_34_173 VPWR VGND sg13g2_fill_2
XFILLER_35_696 VPWR VGND sg13g2_fill_2
X_2888_ net46 VGND VPWR net503 falutop.alu_data_in\[12\] clknet_5_22__leaf_clk sg13g2_dfrbpq_1
X_1908_ VGND VPWR net305 _0433_ _0434_ net296 sg13g2_a21oi_1
X_1839_ _0360_ _0365_ _0366_ VPWR VGND sg13g2_nor2b_1
XFILLER_2_718 VPWR VGND sg13g2_decap_8
XFILLER_1_217 VPWR VGND sg13g2_decap_8
XFILLER_46_939 VPWR VGND sg13g2_decap_8
XFILLER_14_803 VPWR VGND sg13g2_decap_8
XFILLER_14_814 VPWR VGND sg13g2_fill_2
XFILLER_14_836 VPWR VGND sg13g2_decap_8
XFILLER_41_666 VPWR VGND sg13g2_decap_8
XFILLER_40_121 VPWR VGND sg13g2_fill_1
XFILLER_13_379 VPWR VGND sg13g2_decap_8
XFILLER_22_880 VPWR VGND sg13g2_fill_1
XFILLER_21_390 VPWR VGND sg13g2_decap_8
XFILLER_5_567 VPWR VGND sg13g2_decap_8
XFILLER_48_210 VPWR VGND sg13g2_fill_2
XFILLER_1_784 VPWR VGND sg13g2_decap_8
XFILLER_49_755 VPWR VGND sg13g2_decap_8
XFILLER_0_294 VPWR VGND sg13g2_decap_8
XFILLER_37_928 VPWR VGND sg13g2_decap_8
XFILLER_45_994 VPWR VGND sg13g2_decap_8
XFILLER_44_493 VPWR VGND sg13g2_decap_8
XFILLER_16_151 VPWR VGND sg13g2_decap_8
XFILLER_32_622 VPWR VGND sg13g2_fill_1
X_2811_ net59 VGND VPWR net253 falutop.data_in\[4\] clknet_5_9__leaf_clk sg13g2_dfrbpq_2
XFILLER_13_880 VPWR VGND sg13g2_decap_8
XFILLER_20_839 VPWR VGND sg13g2_decap_8
X_2742_ _1129_ net336 net367 VPWR VGND sg13g2_nand2_1
XFILLER_8_361 VPWR VGND sg13g2_decap_8
XFILLER_9_873 VPWR VGND sg13g2_decap_8
X_2673_ _1061_ net283 _1060_ VPWR VGND sg13g2_nand2_1
X_1624_ VGND VPWR _0937_ _1259_ _0155_ _0935_ sg13g2_a21oi_1
X_1555_ _1236_ _1255_ _1256_ VPWR VGND sg13g2_nor2b_1
Xfanout318 falutop.alu_data_in\[15\] net318 VPWR VGND sg13g2_buf_8
Xfanout307 _1045_ net307 VPWR VGND sg13g2_buf_8
Xfanout329 net330 net329 VPWR VGND sg13g2_buf_8
X_1486_ VGND VPWR _0985_ _1068_ _1188_ _0986_ sg13g2_a21oi_1
XFILLER_27_416 VPWR VGND sg13g2_fill_1
X_2107_ VGND VPWR _0717_ net285 _0108_ _0613_ sg13g2_a21oi_1
X_2038_ _0560_ _0528_ _0526_ _0527_ _0972_ VPWR VGND sg13g2_a22oi_1
XFILLER_36_983 VPWR VGND sg13g2_decap_8
XFILLER_35_460 VPWR VGND sg13g2_decap_8
XFILLER_23_644 VPWR VGND sg13g2_decap_8
XFILLER_11_839 VPWR VGND sg13g2_decap_8
XFILLER_22_176 VPWR VGND sg13g2_decap_8
XFILLER_23_677 VPWR VGND sg13g2_fill_1
XFILLER_10_327 VPWR VGND sg13g2_fill_1
XFILLER_6_309 VPWR VGND sg13g2_decap_8
XFILLER_2_515 VPWR VGND sg13g2_decap_8
Xclkbuf_4_13_0_clk clknet_0_clk clknet_4_13_0_clk VPWR VGND sg13g2_buf_8
XFILLER_46_714 VPWR VGND sg13g2_decap_8
XFILLER_18_405 VPWR VGND sg13g2_decap_8
XFILLER_19_928 VPWR VGND sg13g2_decap_8
XFILLER_45_224 VPWR VGND sg13g2_fill_2
XFILLER_14_611 VPWR VGND sg13g2_decap_4
XFILLER_26_62 VPWR VGND sg13g2_decap_8
XFILLER_26_482 VPWR VGND sg13g2_decap_8
XFILLER_42_975 VPWR VGND sg13g2_decap_8
XFILLER_41_441 VPWR VGND sg13g2_fill_1
XFILLER_14_699 VPWR VGND sg13g2_fill_1
XFILLER_42_50 VPWR VGND sg13g2_fill_1
XFILLER_9_136 VPWR VGND sg13g2_decap_4
XFILLER_13_187 VPWR VGND sg13g2_decap_4
XFILLER_10_872 VPWR VGND sg13g2_decap_8
XFILLER_6_832 VPWR VGND sg13g2_decap_8
XFILLER_5_353 VPWR VGND sg13g2_decap_8
XFILLER_47_7 VPWR VGND sg13g2_decap_8
XFILLER_3_11 VPWR VGND sg13g2_decap_8
XFILLER_3_88 VPWR VGND sg13g2_decap_8
XFILLER_1_581 VPWR VGND sg13g2_decap_8
XFILLER_49_552 VPWR VGND sg13g2_decap_8
X_2890__37 VPWR VGND net37 sg13g2_tiehi
XFILLER_18_961 VPWR VGND sg13g2_decap_8
XFILLER_25_909 VPWR VGND sg13g2_decap_8
XFILLER_36_268 VPWR VGND sg13g2_fill_1
XFILLER_17_460 VPWR VGND sg13g2_fill_1
XFILLER_33_931 VPWR VGND sg13g2_decap_8
XFILLER_36_279 VPWR VGND sg13g2_decap_8
XFILLER_20_603 VPWR VGND sg13g2_fill_2
XFILLER_20_614 VPWR VGND sg13g2_decap_8
XFILLER_20_625 VPWR VGND sg13g2_fill_1
XFILLER_32_452 VPWR VGND sg13g2_decap_8
XFILLER_9_670 VPWR VGND sg13g2_decap_8
X_2725_ _1112_ net341 net325 VPWR VGND sg13g2_nand2_1
X_2656_ VGND VPWR net293 _1043_ _0079_ _1044_ sg13g2_a21oi_1
X_1607_ _1307_ net316 net355 net352 VPWR VGND sg13g2_and3_2
X_2587_ net272 _0976_ VPWR VGND sg13g2_inv_4
X_1538_ VGND VPWR _1239_ _1238_ _0927_ sg13g2_or2_1
X_2855__144 VPWR VGND net144 sg13g2_tiehi
XFILLER_47_28 VPWR VGND sg13g2_decap_8
XFILLER_41_1012 VPWR VGND sg13g2_decap_8
X_1469_ _1134_ _1170_ _1171_ VPWR VGND sg13g2_and2_1
XFILLER_28_703 VPWR VGND sg13g2_decap_8
XFILLER_28_725 VPWR VGND sg13g2_decap_8
XFILLER_28_736 VPWR VGND sg13g2_fill_2
XFILLER_43_706 VPWR VGND sg13g2_decap_8
XFILLER_23_430 VPWR VGND sg13g2_fill_1
XFILLER_35_290 VPWR VGND sg13g2_decap_8
XFILLER_23_463 VPWR VGND sg13g2_decap_8
XFILLER_24_975 VPWR VGND sg13g2_decap_8
XFILLER_10_124 VPWR VGND sg13g2_decap_8
XFILLER_3_813 VPWR VGND sg13g2_decap_8
XFILLER_12_75 VPWR VGND sg13g2_decap_4
XFILLER_12_86 VPWR VGND sg13g2_fill_1
XFILLER_2_312 VPWR VGND sg13g2_decap_8
Xhold180 falutop.i2c_inst.result\[4\] VPWR VGND net481 sg13g2_dlygate4sd3_1
XFILLER_2_389 VPWR VGND sg13g2_decap_8
Xhold191 falutop.div_inst.rem\[1\] VPWR VGND net492 sg13g2_dlygate4sd3_1
XFILLER_46_500 VPWR VGND sg13g2_decap_4
X_2910__127 VPWR VGND net127 sg13g2_tiehi
XFILLER_18_224 VPWR VGND sg13g2_decap_4
XFILLER_19_747 VPWR VGND sg13g2_fill_1
XFILLER_18_235 VPWR VGND sg13g2_fill_1
XFILLER_34_717 VPWR VGND sg13g2_fill_2
XFILLER_42_750 VPWR VGND sg13g2_decap_8
XFILLER_15_964 VPWR VGND sg13g2_decap_8
XFILLER_18_1003 VPWR VGND sg13g2_decap_8
XFILLER_33_249 VPWR VGND sg13g2_decap_8
XFILLER_14_474 VPWR VGND sg13g2_decap_8
XFILLER_30_945 VPWR VGND sg13g2_decap_8
X_2510_ net385 VPWR _0907_ VGND net512 net298 sg13g2_o21ai_1
X_2441_ net248 net372 net313 _0043_ VPWR VGND sg13g2_mux2_1
XFILLER_45_4 VPWR VGND sg13g2_fill_2
XFILLER_5_194 VPWR VGND sg13g2_decap_8
X_2372_ VGND VPWR _0713_ net314 _0018_ _0821_ sg13g2_a21oi_1
XFILLER_25_1007 VPWR VGND sg13g2_decap_8
XFILLER_49_382 VPWR VGND sg13g2_decap_8
XFILLER_37_566 VPWR VGND sg13g2_fill_1
XFILLER_25_717 VPWR VGND sg13g2_decap_4
XFILLER_37_588 VPWR VGND sg13g2_fill_1
XFILLER_24_205 VPWR VGND sg13g2_decap_8
XFILLER_33_783 VPWR VGND sg13g2_decap_8
XFILLER_21_967 VPWR VGND sg13g2_decap_8
XFILLER_20_477 VPWR VGND sg13g2_fill_2
X_2708_ VPWR VGND _0931_ _1087_ _1016_ _0934_ _1096_ _1012_ sg13g2_a221oi_1
XFILLER_3_109 VPWR VGND sg13g2_decap_8
XFILLER_0_805 VPWR VGND sg13g2_decap_8
X_2639_ VGND VPWR _0720_ net315 _1028_ net324 sg13g2_a21oi_1
XFILLER_28_544 VPWR VGND sg13g2_decap_4
XFILLER_28_555 VPWR VGND sg13g2_decap_4
XFILLER_15_205 VPWR VGND sg13g2_decap_8
XFILLER_16_717 VPWR VGND sg13g2_decap_8
XFILLER_43_569 VPWR VGND sg13g2_fill_1
XFILLER_24_761 VPWR VGND sg13g2_decap_8
XFILLER_12_934 VPWR VGND sg13g2_decap_8
XFILLER_11_444 VPWR VGND sg13g2_fill_2
XFILLER_11_466 VPWR VGND sg13g2_decap_8
XFILLER_7_437 VPWR VGND sg13g2_decap_8
XFILLER_23_96 VPWR VGND sg13g2_decap_8
XFILLER_3_610 VPWR VGND sg13g2_decap_8
XFILLER_3_687 VPWR VGND sg13g2_decap_8
XFILLER_2_186 VPWR VGND sg13g2_decap_8
XFILLER_38_319 VPWR VGND sg13g2_decap_4
XFILLER_19_511 VPWR VGND sg13g2_decap_8
XFILLER_47_875 VPWR VGND sg13g2_decap_8
XFILLER_0_56 VPWR VGND sg13g2_decap_8
XFILLER_15_772 VPWR VGND sg13g2_decap_8
X_1941_ _0466_ _0464_ _0465_ VPWR VGND sg13g2_xnor2_1
XFILLER_9_32 VPWR VGND sg13g2_decap_8
X_1872_ _0398_ net320 net355 VPWR VGND sg13g2_nand2_1
XFILLER_30_786 VPWR VGND sg13g2_fill_2
XFILLER_31_1011 VPWR VGND sg13g2_decap_8
X_2424_ net175 net290 _0027_ VPWR VGND sg13g2_nor2_1
X_2355_ _0806_ VPWR _0013_ VGND _0731_ _0809_ sg13g2_o21ai_1
XFILLER_36_0 VPWR VGND sg13g2_decap_8
X_2286_ net186 _0739_ _0751_ VPWR VGND sg13g2_nor2_1
XFILLER_49_190 VPWR VGND sg13g2_decap_8
XFILLER_38_875 VPWR VGND sg13g2_decap_8
XFILLER_37_330 VPWR VGND sg13g2_decap_8
XFILLER_25_514 VPWR VGND sg13g2_decap_8
XFILLER_20_252 VPWR VGND sg13g2_decap_8
XFILLER_20_274 VPWR VGND sg13g2_fill_1
XFILLER_4_418 VPWR VGND sg13g2_decap_8
XFILLER_0_602 VPWR VGND sg13g2_decap_8
XFILLER_0_679 VPWR VGND sg13g2_decap_8
XFILLER_47_116 VPWR VGND sg13g2_decap_8
XFILLER_44_867 VPWR VGND sg13g2_decap_8
XFILLER_43_344 VPWR VGND sg13g2_fill_2
XFILLER_43_322 VPWR VGND sg13g2_fill_1
XFILLER_16_558 VPWR VGND sg13g2_decap_8
XFILLER_18_96 VPWR VGND sg13g2_fill_2
XFILLER_28_396 VPWR VGND sg13g2_decap_8
XFILLER_34_62 VPWR VGND sg13g2_decap_8
XFILLER_12_753 VPWR VGND sg13g2_decap_8
XFILLER_15_1006 VPWR VGND sg13g2_decap_8
XFILLER_8_768 VPWR VGND sg13g2_decap_8
XFILLER_4_985 VPWR VGND sg13g2_decap_8
XFILLER_3_484 VPWR VGND sg13g2_decap_8
X_2140_ net242 net292 _0634_ VPWR VGND sg13g2_nor2_1
XFILLER_19_330 VPWR VGND sg13g2_decap_8
X_2071_ _0592_ net370 _0579_ VPWR VGND sg13g2_nand2_1
XFILLER_35_801 VPWR VGND sg13g2_decap_8
XFILLER_34_377 VPWR VGND sg13g2_decap_8
XFILLER_35_878 VPWR VGND sg13g2_decap_8
X_1924_ _0449_ _0448_ _0404_ VPWR VGND sg13g2_nand2b_1
XFILLER_15_591 VPWR VGND sg13g2_decap_4
XFILLER_30_572 VPWR VGND sg13g2_decap_8
XFILLER_30_583 VPWR VGND sg13g2_fill_2
X_1855_ VGND VPWR _0334_ _0378_ _0382_ _1019_ sg13g2_a21oi_1
X_1786_ net332 net329 net354 net351 _0314_ VPWR VGND sg13g2_and4_1
X_2407_ VGND VPWR _0832_ net297 _0024_ _0850_ sg13g2_a21oi_1
X_2338_ _0796_ _0787_ _0795_ VPWR VGND sg13g2_nand2_1
XFILLER_38_650 VPWR VGND sg13g2_decap_4
X_2269_ _0737_ net375 _0734_ VPWR VGND sg13g2_nand2_2
XFILLER_44_119 VPWR VGND sg13g2_decap_8
XFILLER_25_311 VPWR VGND sg13g2_decap_4
XFILLER_26_845 VPWR VGND sg13g2_decap_8
XFILLER_26_856 VPWR VGND sg13g2_fill_2
XFILLER_26_889 VPWR VGND sg13g2_decap_8
XFILLER_40_314 VPWR VGND sg13g2_decap_8
XFILLER_25_399 VPWR VGND sg13g2_decap_8
XFILLER_5_749 VPWR VGND sg13g2_decap_8
XFILLER_4_259 VPWR VGND sg13g2_decap_8
XFILLER_20_53 VPWR VGND sg13g2_decap_8
XFILLER_1_966 VPWR VGND sg13g2_decap_8
XFILLER_49_937 VPWR VGND sg13g2_decap_8
Xhold40 falutop.i2c_inst.data_in\[16\] VPWR VGND net214 sg13g2_dlygate4sd3_1
XFILLER_0_476 VPWR VGND sg13g2_decap_8
Xhold73 _0029_ VPWR VGND net247 sg13g2_dlygate4sd3_1
Xhold62 falutop.div_inst.acc\[3\] VPWR VGND net236 sg13g2_dlygate4sd3_1
Xhold51 _0009_ VPWR VGND net225 sg13g2_dlygate4sd3_1
Xhold84 _0031_ VPWR VGND net258 sg13g2_dlygate4sd3_1
XFILLER_29_650 VPWR VGND sg13g2_fill_1
Xhold95 _0122_ VPWR VGND net396 sg13g2_dlygate4sd3_1
XFILLER_29_694 VPWR VGND sg13g2_decap_8
XFILLER_45_61 VPWR VGND sg13g2_decap_8
XFILLER_17_889 VPWR VGND sg13g2_decap_8
XFILLER_45_94 VPWR VGND sg13g2_fill_1
XFILLER_40_870 VPWR VGND sg13g2_decap_8
XFILLER_8_532 VPWR VGND sg13g2_fill_1
XFILLER_12_594 VPWR VGND sg13g2_decap_8
XFILLER_8_565 VPWR VGND sg13g2_decap_8
XFILLER_6_11 VPWR VGND sg13g2_decap_8
X_1640_ net389 VPWR _0171_ VGND net463 net293 sg13g2_o21ai_1
X_1571_ net304 _1271_ net175 _1272_ VPWR VGND sg13g2_nand3_1
XFILLER_4_782 VPWR VGND sg13g2_decap_8
XFILLER_39_447 VPWR VGND sg13g2_decap_8
X_2123_ net210 net292 _0622_ VPWR VGND sg13g2_nor2_1
X_2054_ _0339_ VPWR _0576_ VGND _0574_ _0575_ sg13g2_o21ai_1
XFILLER_22_358 VPWR VGND sg13g2_fill_1
X_1907_ _0433_ falutop.div_inst.rem\[2\] _0431_ VPWR VGND sg13g2_xnor2_1
XFILLER_31_892 VPWR VGND sg13g2_decap_8
X_2887_ net65 VGND VPWR net509 falutop.alu_data_in\[11\] clknet_5_28__leaf_clk sg13g2_dfrbpq_2
X_1838_ _0364_ _0201_ _0365_ VPWR VGND sg13g2_xor2_1
X_1769_ _0298_ net203 _0297_ VPWR VGND sg13g2_xnor2_1
XFILLER_44_1021 VPWR VGND sg13g2_decap_8
XFILLER_46_918 VPWR VGND sg13g2_decap_8
Xheichips25_template_20 VPWR VGND uio_out[7] sg13g2_tielo
XFILLER_38_491 VPWR VGND sg13g2_decap_4
XFILLER_17_119 VPWR VGND sg13g2_decap_8
XFILLER_40_100 VPWR VGND sg13g2_decap_8
XFILLER_15_31 VPWR VGND sg13g2_decap_8
XFILLER_26_686 VPWR VGND sg13g2_decap_8
X_2865__124 VPWR VGND net124 sg13g2_tiehi
XFILLER_41_656 VPWR VGND sg13g2_fill_1
XFILLER_41_645 VPWR VGND sg13g2_decap_8
X_2906__143 VPWR VGND net143 sg13g2_tiehi
XFILLER_5_546 VPWR VGND sg13g2_decap_8
XFILLER_31_74 VPWR VGND sg13g2_fill_2
XFILLER_31_85 VPWR VGND sg13g2_fill_2
XFILLER_1_763 VPWR VGND sg13g2_decap_8
XFILLER_49_734 VPWR VGND sg13g2_decap_8
XFILLER_0_273 VPWR VGND sg13g2_decap_8
XFILLER_37_907 VPWR VGND sg13g2_decap_8
X_2887__65 VPWR VGND net65 sg13g2_tiehi
XFILLER_17_620 VPWR VGND sg13g2_decap_8
XFILLER_45_973 VPWR VGND sg13g2_decap_8
XFILLER_16_130 VPWR VGND sg13g2_decap_8
XFILLER_31_100 VPWR VGND sg13g2_decap_4
XFILLER_32_601 VPWR VGND sg13g2_decap_8
XFILLER_31_111 VPWR VGND sg13g2_decap_8
XFILLER_32_634 VPWR VGND sg13g2_decap_8
X_2810_ net60 VGND VPWR net258 falutop.data_in\[3\] clknet_5_14__leaf_clk sg13g2_dfrbpq_2
XFILLER_20_818 VPWR VGND sg13g2_decap_8
XFILLER_9_852 VPWR VGND sg13g2_decap_8
X_2741_ VGND VPWR _1126_ _1127_ _1128_ _1124_ sg13g2_a21oi_1
X_2672_ net366 net338 net271 _1060_ VPWR VGND sg13g2_mux2_1
X_1623_ VGND VPWR _0719_ net271 _0154_ _0153_ sg13g2_a21oi_1
X_1554_ _1253_ _1237_ _1255_ VPWR VGND sg13g2_xor2_1
Xfanout308 _0930_ net308 VPWR VGND sg13g2_buf_8
X_1485_ net319 VPWR _1187_ VGND net323 net315 sg13g2_o21ai_1
Xfanout319 net322 net319 VPWR VGND sg13g2_buf_8
.ends
